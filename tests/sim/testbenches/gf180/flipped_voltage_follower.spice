* Testbench: flipped voltage follower — gf180 (3.3 V, nfet_03v3)
* DUT subckt: FLIPPED_VOLTAGE_FOLLOWER VIN VBULK VOUT Ib
*   X0: D=Ib G=VIN S=VOUT; X1: D=VOUT G=Ib S=VBULK. Bias current is injected
*   into the Ib node (drain of X0 / gate of X1); VBULK is the ground rail.
*
* Functional check: the FVF is a level-shifting follower, so VOUT should
* track VIN with near-unity slope and a roughly constant Vgs level shift.
* follow_slope = dVOUT/dVIN across the follow window; level_shift =
* VIN - VOUT at the window's midpoint.
*
* The follow window is bounded above by X0 leaving saturation (its drain
* sits at V(Ib) ~= one Vgs), so the sweep/probe points live in the low-VIN
* region. If the first run shows the AT points outside the linear region,
* nudge them and recalibrate the bands.
*
* run_cell_sim.py injects the gf180 model setup and .includes the DUT
* netlist, so this file is stimulus + analysis ONLY.
.param IB=10u
* Ground rail / bulk.
Vbulk VBULK 0 DC 0
* Bias: push IB into the Ib node.
Ibias 0 NBIAS DC {IB}
* Convergence aid: gives the ideal current source a DC path when both
* devices are off at the low end of the sweep. 100Meg draws ~10 pA at the
* operating point -- negligible vs IB.
Rconv NBIAS 0 100Meg
* Swept input.
Vin VIN 0 DC 0
* DUT: VIN VBULK VOUT Ib
X1 VIN VBULK VOUT NBIAS FLIPPED_VOLTAGE_FOLLOWER
.dc Vin 0.9 2.0 0.005
* Follow window probes (literals; keep consistent with the slope divisor).
.measure dc vout_a  FIND v(VOUT) AT=1.0
.measure dc vout_b  FIND v(VOUT) AT=1.4
.measure dc follow_slope param='(vout_b - vout_a)/0.4'
* Level shift (~Vgs of X0) at the window midpoint; literal 1.2 = AT point.
.measure dc vout_ls FIND v(VOUT) AT=1.2
.measure dc level_shift param='1.2 - vout_ls'
.end
