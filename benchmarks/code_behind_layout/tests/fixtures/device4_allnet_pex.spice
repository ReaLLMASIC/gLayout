* NGSPICE file created from device4_rc.ext - technology: sky130A

.subckt device4_rc D B S G
X0 S.t1 G.t0 D.t1 B.t1 sky130_fd_pr__nfet_01v8 ad=1.17 pd=6.78 as=0.495 ps=3.33 w=3 l=0.5
X1 D.t0 G.t1 S.t0 B.t0 sky130_fd_pr__nfet_01v8 ad=0.495 pd=3.33 as=1.17 ps=6.78 w=3 l=0.5
R0 G G.n1 0.063
R1 G G.n1 0.0383788
R2 G.n1 G.n0 70.3711
R3 G.n0 G.t0 244.149
R4 G.n0 G.t1 244.124
R5 D.n0 D 85.2063
R6 D.t0 D.n0 6.6005
R7 D.n0 D.t1 6.6005
R8 S S.n0 0.1255
R9 S S.n0 0.0436034
R10 S.n0 S.t1 75.4824
R11 S S.t0 75.4393
R12 B B.n290 6.4005
R13 B.n3 B.n1 71.676
R14 B.n2 B.n1 585
R15 B.n0 B.n3 256.663
R16 B.n5 B.n4 585
R17 B.n8 B.n6 71.676
R18 B.n7 B.n6 585
R19 B.n0 B.n8 256.663
R20 B.n10 B.n9 585
R21 B.n13 B.n11 71.676
R22 B.n12 B.n11 585
R23 B.n0 B.n13 256.663
R24 B.n15 B.n14 585
R25 B.n18 B.n16 71.676
R26 B.n17 B.n16 585
R27 B.n0 B.n18 256.663
R28 B.n20 B.n19 585
R29 B.n21 B.n23 71.676
R30 B.n22 B.n21 585
R31 B.n23 B.n0 256.663
R32 B.n25 B.n24 585
R33 B.n26 B.n28 71.676
R34 B.n27 B.n26 585
R35 B.n0 B.n28 256.663
R36 B.n30 B.n29 585
R37 B.n31 B.n33 71.676
R38 B.n32 B.n31 585
R39 B.n0 B.n33 256.663
R40 B.n35 B.n34 585
R41 B.n36 B.n38 71.676
R42 B.n37 B.n36 585
R43 B.n0 B.n38 256.663
R44 B.n40 B.n39 585
R45 B.n40 B.n93 31.1225
R46 B.n37 B.n40 10.6151
R47 B.n35 B.n37 10.6151
R48 B.n32 B.n35 10.6151
R49 B.n30 B.n32 10.6151
R50 B.n27 B.n30 10.6151
R51 B.n25 B.n27 10.6151
R52 B.n22 B.n25 10.6151
R53 B B.n22 2.18587
R54 B B.n290 3.12245
R55 B.n290 B.n20 5.30782
R56 B.n20 B.n17 10.6151
R57 B.n17 B.n15 10.6151
R58 B.n15 B.n12 10.6151
R59 B.n12 B.n10 10.6151
R60 B.n10 B.n7 10.6151
R61 B.n7 B.n5 10.6151
R62 B.n5 B.n2 10.6151
R63 B.n2 B.n43 31.1225
R64 B.n42 B.n41 9.3005
R65 B.n43 B.n287 9.3005
R66 B.n45 B.n44 9.3005
R67 B.n47 B.n46 9.3005
R68 B.n49 B.n48 9.3005
R69 B.n43 B.n45 0.152939
R70 B.n45 B.n47 0.152939
R71 B.n47 B.n49 0.152939
R72 B.n49 B.n42 0.152939
R73 B.n86 B.n50 585
R74 B.n51 B.n50 585
R75 B.n52 B.n80 71.676
R76 B.n53 B.n52 585
R77 B.n86 B.n80 256.663
R78 B.n55 B.n54 585
R79 B.n56 B.n81 71.676
R80 B.n57 B.n56 585
R81 B.n86 B.n81 256.663
R82 B.n59 B.n58 585
R83 B.n60 B.n82 71.676
R84 B.n61 B.n60 585
R85 B.n86 B.n82 256.663
R86 B.n63 B.n62 585
R87 B.n64 B.n83 71.676
R88 B.n65 B.n64 585
R89 B.n86 B.n83 256.663
R90 B.n67 B.n66 585
R91 B.n84 B.n68 71.676
R92 B.n69 B.n68 585
R93 B.n86 B.n84 256.663
R94 B.n71 B.n70 585
R95 B.n85 B.n72 71.676
R96 B.n73 B.n72 585
R97 B.n86 B.n85 256.663
R98 B.n75 B.n74 585
R99 B.n86 B.n76 585
R100 B.n77 B.n76 585
R101 B.n87 B.n78 71.676
R102 B.n79 B.n78 585
R103 B.n87 B.n86 256.663
R104 B.n89 B.n88 585
R105 B.n91 B.n51 31.1225
R106 B.n51 B.n53 10.6151
R107 B.n53 B.n55 10.6151
R108 B.n55 B.n57 10.6151
R109 B.n57 B.n59 10.6151
R110 B.n59 B.n61 10.6151
R111 B.n61 B.n63 10.6151
R112 B.n63 B.n65 10.6151
R113 B.n65 B.n67 10.6151
R114 B.n69 B.n67 10.6151
R115 B.n71 B.n69 10.6151
R116 B.n73 B.n71 10.6151
R117 B.n75 B.n73 10.6151
R118 B.n77 B.n75 10.6151
R119 B.n79 B.n77 10.6151
R120 B.n89 B.n79 10.6151
R121 B.n42 B.n89 31.1225
R122 B.n91 B.n90 9.3005
R123 B.n93 B.n92 9.3005
R124 B.n95 B.n94 9.3005
R125 B.n97 B.n96 9.3005
R126 B.n289 B.n98 9.3005
R127 B.n93 B.n95 0.152939
R128 B.n95 B.n97 0.152939
R129 B.n97 B.n289 0.152939
R130 B.n289 B.n91 0.152939
R131 B.n99 B.n125 585
R132 B.n90 B.n99 585
R133 B.n100 B.n122 585
R134 B.n98 B.n100 585
R135 B.n101 B.n119 585
R136 B.n96 B.n101 585
R137 B.n102 B.n116 585
R138 B.n94 B.n102 585
R139 B.n288 B.n107 585
R140 B.n92 B.n288 585
R141 B.n92 B.n94 19.3944
R142 B.n94 B.n96 19.3944
R143 B.n96 B.n98 19.3944
R144 B.n98 B.n90 19.3944
R145 B.n288 B.n102 240.244
R146 B.n102 B.n101 240.244
R147 B.n101 B.n100 240.244
R148 B.n100 B.n99 240.244
R149 B.n288 B.n39 675.086
R150 B.n39 B.n38 71.676
R151 B.n36 B.n34 163.367
R152 B.n34 B.n33 71.676
R153 B.n31 B.n29 163.367
R154 B.n29 B.n28 71.676
R155 B.n26 B.n24 163.367
R156 B.n24 B.n23 71.676
R157 B.n21 B.n19 163.367
R158 B.n19 B.n18 71.676
R159 B.n16 B.n14 163.367
R160 B.n14 B.n13 71.676
R161 B.n11 B.n9 163.367
R162 B.n9 B.n8 71.676
R163 B.n6 B.n4 163.367
R164 B.n4 B.n3 71.676
R165 B.n125 B.n103 585
R166 B.n41 B.n103 585
R167 B.n122 B.n104 585
R168 B.n48 B.n104 585
R169 B.n119 B.n105 585
R170 B.n46 B.n105 585
R171 B.n116 B.n106 585
R172 B.n44 B.n106 585
R173 B.n107 B.n286 585
R174 B.n287 B.n286 585
R175 B.n1 B.n286 675.086
R176 B.n286 B.n106 240.244
R177 B.n106 B.n105 240.244
R178 B.n105 B.n104 240.244
R179 B.n104 B.n103 240.244
R180 B.n99 B.n50 675.086
R181 B.n50 B.n52 163.367
R182 B.n80 B.n54 71.676
R183 B.n54 B.n56 163.367
R184 B.n81 B.n58 71.676
R185 B.n58 B.n60 163.367
R186 B.n82 B.n62 71.676
R187 B.n62 B.n64 163.367
R188 B.n83 B.n66 71.676
R189 B.n66 B.n68 163.367
R190 B.n70 B.n84 71.676
R191 B.n70 B.n72 163.367
R192 B.n74 B.n85 71.676
R193 B.n74 B.n76 163.367
R194 B.n76 B.n78 163.367
R195 B.n88 B.n87 71.676
R196 B.n88 B.n103 675.086
R197 B.n287 B.n44 19.3944
R198 B.n44 B.n46 19.3944
R199 B.n46 B.n48 19.3944
R200 B.n48 B.n41 19.3944
R201 B.n108 B.n109 585
R202 B.n109 B.n110 585
R203 B.n111 B.n112 585
R204 B.n112 B.n113 585
R205 B.n107 B.n114 585
R206 B.n114 B.n115 585
R207 B.n116 B.n117 585
R208 B.n117 B.n118 585
R209 B.n119 B.n120 585
R210 B.n120 B.n121 585
R211 B.n122 B.n123 585
R212 B.n123 B.n124 585
R213 B.n125 B.n126 585
R214 B.n126 B.n127 585
R215 B.n128 B.n129 585
R216 B.n129 B.n130 585
R217 B.n131 B.n132 585
R218 B.n132 B.n273 585
R219 B.n131 B.n133 585
R220 B.n133 B.n134 585
R221 B.n128 B.n135 585
R222 B.n135 B.n283 585
R223 B.n125 B.n136 585
R224 B.n136 B.n137 585
R225 B.n122 B.n138 585
R226 B.n138 B.n139 585
R227 B.n119 B.n140 585
R228 B.n140 B.n141 585
R229 B.n116 B.n142 585
R230 B.n142 B.n143 585
R231 B.n107 B.n144 585
R232 B.n144 B.n145 585
R233 B.n111 B.n146 585
R234 B.n146 B.n147 585
R235 B.n108 B.n148 585
R236 B.n148 B.n149 585
R237 B.n150 B.n151 585
R238 B.n151 B.n152 585
R239 B.n155 B.n153 71.676
R240 B.n153 B.n154 585
R241 B.n150 B.n155 256.663
R242 B.n156 B.n157 585
R243 B.n160 B.n158 71.676
R244 B.n158 B.n159 585
R245 B.n150 B.n160 256.663
R246 B.n161 B.n162 585
R247 B.n165 B.n163 71.676
R248 B.n163 B.n164 585
R249 B.n150 B.n165 256.663
R250 B.n166 B.n167 585
R251 B.n170 B.n168 71.676
R252 B.n168 B.n169 585
R253 B.n150 B.n170 256.663
R254 B.n171 B.n172 585
R255 B.n175 B.n173 71.676
R256 B.n173 B.n174 585
R257 B.n150 B.n175 256.663
R258 B.n176 B.n177 585
R259 B.n180 B.n178 71.676
R260 B.n178 B.n179 585
R261 B.n150 B.n180 256.663
R262 B.n181 B.n182 585
R263 B.n185 B.n183 71.676
R264 B.n183 B.n184 585
R265 B.n150 B.n185 256.663
R266 B.n186 B.n187 585
R267 B.n190 B.n188 71.676
R268 B.n188 B.n189 585
R269 B.n150 B.n190 256.663
R270 B.n191 B.n192 585
R271 B.n195 B.n193 71.676
R272 B.n193 B.n194 585
R273 B.n150 B.n195 256.663
R274 B.n196 B.n197 585
R275 B.n200 B.n198 71.676
R276 B.n198 B.n199 585
R277 B.n150 B.n200 256.663
R278 B.n201 B.n202 585
R279 B.n205 B.n203 71.676
R280 B.n203 B.n204 585
R281 B.n150 B.n205 256.663
R282 B.n206 B.n207 585
R283 B.n252 B.n208 71.676
R284 B.n208 B.n209 585
R285 B.n262 B.n252 256.663
R286 B.n210 B.n211 585
R287 B.n253 B.n212 71.676
R288 B.n212 B.n213 585
R289 B.n262 B.n253 256.663
R290 B.n214 B.n215 585
R291 B.n254 B.n216 71.676
R292 B.n216 B.n217 585
R293 B.n262 B.n254 256.663
R294 B.n218 B.n219 585
R295 B.n255 B.n220 71.676
R296 B.n220 B.n221 585
R297 B.n262 B.n255 256.663
R298 B.n222 B.n223 585
R299 B.n256 B.n224 71.676
R300 B.n224 B.n225 585
R301 B.n262 B.n256 256.663
R302 B.n226 B.n227 585
R303 B.n257 B.n228 71.676
R304 B.n228 B.n229 585
R305 B.n262 B.n257 256.663
R306 B.n230 B.n231 585
R307 B.n258 B.n232 71.676
R308 B.n232 B.n233 585
R309 B.n262 B.n258 256.663
R310 B.n234 B.n235 585
R311 B.n259 B.n236 71.676
R312 B.n236 B.n237 585
R313 B.n262 B.n259 256.663
R314 B.n238 B.n239 585
R315 B.n260 B.n240 71.676
R316 B.n240 B.n241 585
R317 B.n262 B.n260 256.663
R318 B.n242 B.n243 585
R319 B.n261 B.n244 71.676
R320 B.n244 B.n245 585
R321 B.n262 B.n261 256.663
R322 B.n246 B.n247 585
R323 B.n262 B.n248 585
R324 B.n248 B.n249 585
R325 B.n263 B.n250 71.676
R326 B.n250 B.n251 585
R327 B.n262 B.n263 256.663
R328 B.n264 B.n285 585
R329 B.n108 B.n150 465.156
R330 B.n0 B.n108 37.9725
R331 B.n0 B.n111 199.353
R332 B.n111 B.n107 237.326
R333 B.n107 B.n116 237.326
R334 B.n116 B.t0 40.3457
R335 B.t0 B.n119 196.981
R336 B.n119 B.t1 196.981
R337 B.n122 B.t1 40.3457
R338 B.n122 B.n125 237.326
R339 B.n125 B.n128 237.326
R340 B.n86 B.n128 199.353
R341 B.n86 B.n131 37.9725
R342 B.n131 B.n262 465.156
R343 B.n275 B.n209 27.0822
R344 B.n209 B.n211 10.6151
R345 B.n211 B.n213 10.6151
R346 B.n213 B.n215 10.6151
R347 B.n215 B.n217 10.6151
R348 B.n217 B.n219 10.6151
R349 B.n219 B.n221 10.6151
R350 B.n221 B.n223 10.6151
R351 B.n223 B.n225 10.6151
R352 B.n225 B.n227 10.6151
R353 B.n227 B.n229 10.6151
R354 B.n229 B.n231 10.6151
R355 B.n233 B.n231 10.6151
R356 B.n235 B.n233 10.6151
R357 B.n237 B.n235 10.6151
R358 B.n239 B.n237 10.6151
R359 B.n241 B.n239 10.6151
R360 B.n243 B.n241 10.6151
R361 B.n245 B.n243 10.6151
R362 B.n247 B.n245 10.6151
R363 B.n249 B.n247 10.6151
R364 B.n251 B.n249 10.6151
R365 B.n285 B.n251 10.6151
R366 B.n274 B.n285 27.0822
R367 B.n110 B.n265 9.3005
R368 B.n266 B.n113 9.3005
R369 B.n267 B.n115 9.3005
R370 B.n268 B.n118 9.3005
R371 B.n269 B.n121 9.3005
R372 B.n270 B.n124 9.3005
R373 B.n271 B.n127 9.3005
R374 B.n272 B.n130 9.3005
R375 B.n274 B.n273 9.3005
R376 B.n265 B.n266 0.152939
R377 B.n266 B.n267 0.152939
R378 B.n267 B.n268 0.152939
R379 B.n268 B.n269 0.152939
R380 B.n269 B.n270 0.152939
R381 B.n270 B.n271 0.152939
R382 B.n271 B.n272 0.152939
R383 B.n272 B.n274 0.152939
R384 B.n276 B.n207 27.0822
R385 B.n207 B.n204 10.6151
R386 B.n204 B.n202 10.6151
R387 B.n202 B.n199 10.6151
R388 B.n199 B.n197 10.6151
R389 B.n197 B.n194 10.6151
R390 B.n194 B.n192 10.6151
R391 B.n192 B.n189 10.6151
R392 B.n189 B.n187 10.6151
R393 B.n187 B.n184 10.6151
R394 B.n184 B.n182 10.6151
R395 B.n182 B.n179 10.6151
R396 B.n177 B.n179 10.6151
R397 B.n174 B.n177 10.6151
R398 B.n172 B.n174 10.6151
R399 B.n169 B.n172 10.6151
R400 B.n167 B.n169 10.6151
R401 B.n164 B.n167 10.6151
R402 B.n162 B.n164 10.6151
R403 B.n159 B.n162 10.6151
R404 B.n157 B.n159 10.6151
R405 B.n154 B.n157 10.6151
R406 B.n152 B.n154 10.6151
R407 B.n265 B.n152 27.0822
R408 B.n275 B.n134 9.3005
R409 B.n149 B.n276 9.3005
R410 B.n277 B.n147 9.3005
R411 B.n278 B.n145 9.3005
R412 B.n279 B.n143 9.3005
R413 B.n280 B.n141 9.3005
R414 B.n281 B.n139 9.3005
R415 B.n282 B.n137 9.3005
R416 B.n284 B.n283 9.3005
R417 B.n276 B.n277 0.152939
R418 B.n277 B.n278 0.152939
R419 B.n278 B.n279 0.152939
R420 B.n279 B.n280 0.152939
R421 B.n280 B.n281 0.152939
R422 B.n281 B.n282 0.152939
R423 B.n282 B.n284 0.152939
R424 B.n284 B.n275 0.152939
R425 B.n149 B.n147 19.3944
R426 B.n147 B.n145 19.3944
R427 B.n145 B.n143 19.3944
R428 B.n143 B.n141 19.3944
R429 B.n141 B.n139 19.3944
R430 B.n139 B.n137 19.3944
R431 B.n137 B.n283 19.3944
R432 B.n283 B.n134 19.3944
R433 B.n110 B.n113 19.3944
R434 B.n113 B.n115 19.3944
R435 B.n115 B.n118 19.3944
R436 B.n118 B.n121 19.3944
R437 B.n121 B.n124 19.3944
R438 B.n124 B.n127 19.3944
R439 B.n127 B.n130 19.3944
R440 B.n130 B.n273 19.3944
R441 B.n252 B.n210 71.676
R442 B.n210 B.n212 163.367
R443 B.n253 B.n214 71.676
R444 B.n214 B.n216 163.367
R445 B.n254 B.n218 71.676
R446 B.n218 B.n220 163.367
R447 B.n255 B.n222 71.676
R448 B.n222 B.n224 163.367
R449 B.n256 B.n226 71.676
R450 B.n226 B.n228 163.367
R451 B.n257 B.n230 71.676
R452 B.n230 B.n232 163.367
R453 B.n258 B.n234 71.676
R454 B.n234 B.n236 163.367
R455 B.n259 B.n238 71.676
R456 B.n238 B.n240 163.367
R457 B.n260 B.n242 71.676
R458 B.n242 B.n244 163.367
R459 B.n261 B.n246 71.676
R460 B.n246 B.n248 163.367
R461 B.n250 B.n248 163.367
R462 B.n263 B.n264 71.676
R463 B.n148 B.n146 240.244
R464 B.n146 B.n144 240.244
R465 B.n144 B.n142 240.244
R466 B.n142 B.n140 240.244
R467 B.n140 B.n138 240.244
R468 B.n138 B.n136 240.244
R469 B.n136 B.n135 240.244
R470 B.n135 B.n133 240.244
R471 B.n133 B.n208 641.452
R472 B.n148 B.n206 641.452
R473 B.n205 B.n206 71.676
R474 B.n203 B.n201 163.367
R475 B.n200 B.n201 71.676
R476 B.n198 B.n196 163.367
R477 B.n195 B.n196 71.676
R478 B.n193 B.n191 163.367
R479 B.n190 B.n191 71.676
R480 B.n188 B.n186 163.367
R481 B.n185 B.n186 71.676
R482 B.n183 B.n181 163.367
R483 B.n180 B.n181 71.676
R484 B.n178 B.n176 163.367
R485 B.n175 B.n176 71.676
R486 B.n173 B.n171 163.367
R487 B.n170 B.n171 71.676
R488 B.n168 B.n166 163.367
R489 B.n165 B.n166 71.676
R490 B.n163 B.n161 163.367
R491 B.n160 B.n161 71.676
R492 B.n158 B.n156 163.367
R493 B.n155 B.n156 71.676
R494 B.n153 B.n151 163.367
R495 B.n151 B.n109 641.452
R496 B.n109 B.n112 240.244
R497 B.n112 B.n114 240.244
R498 B.n114 B.n117 240.244
R499 B.n117 B.n120 240.244
R500 B.n120 B.n123 240.244
R501 B.n123 B.n126 240.244
R502 B.n126 B.n129 240.244
R503 B.n129 B.n132 240.244
R504 B.n132 B.n264 641.452
C0 D B 0.23844f
C1 S D 0.90977f
C2 B G 0.6245f
C3 dw_n487_n751# B 4.38884f
C4 S G 0.2984f
C5 S B 0.52174f
C6 D G 0.26813f
C7 D a_n637_n901# 0.01648f
C8 S a_n637_n901# 0.15434f
C9 G a_n637_n901# 0.17574f
C10 B a_n637_n901# 1.66602f
C11 dw_n487_n751# a_n637_n901# 4.38884f $ **FLOATING
C12 B.n0 a_n637_n901# 0.0944f
C13 B.n1 a_n637_n901# 0.01681f
C14 B.n2 a_n637_n901# 0.01153f
C15 B.n4 a_n637_n901# 0.00568f
C16 B.n5 a_n637_n901# 0.00568f
C17 B.n6 a_n637_n901# 0.00568f
C18 B.n7 a_n637_n901# 0.00568f
C19 B.n9 a_n637_n901# 0.00568f
C20 B.n10 a_n637_n901# 0.00568f
C21 B.n11 a_n637_n901# 0.00568f
C22 B.n12 a_n637_n901# 0.00568f
C23 B.n14 a_n637_n901# 0.00568f
C24 B.n15 a_n637_n901# 0.00568f
C25 B.n16 a_n637_n901# 0.00568f
C26 B.n17 a_n637_n901# 0.00568f
C27 B.n19 a_n637_n901# 0.00568f
C28 B.n20 a_n637_n901# 0.00426f
C29 B.n21 a_n637_n901# 0.00568f
C30 B.n22 a_n637_n901# 0.00342f
C31 B.n24 a_n637_n901# 0.00568f
C32 B.n25 a_n637_n901# 0.00568f
C33 B.n26 a_n637_n901# 0.00568f
C34 B.n27 a_n637_n901# 0.00568f
C35 B.n29 a_n637_n901# 0.00568f
C36 B.n30 a_n637_n901# 0.00568f
C37 B.n31 a_n637_n901# 0.00568f
C38 B.n32 a_n637_n901# 0.00568f
C39 B.n34 a_n637_n901# 0.00568f
C40 B.n35 a_n637_n901# 0.00568f
C41 B.n36 a_n637_n901# 0.00568f
C42 B.n37 a_n637_n901# 0.00568f
C43 B.n39 a_n637_n901# 0.01681f
C44 B.n40 a_n637_n901# 0.01153f
C45 B.n41 a_n637_n901# 0.00558f
C46 B.n42 a_n637_n901# 0.02922f
C47 B.n43 a_n637_n901# 0.02922f
C48 B.n44 a_n637_n901# 0.00672f
C49 B.n45 a_n637_n901# 0.00835f
C50 B.n46 a_n637_n901# 0.00672f
C51 B.n47 a_n637_n901# 0.00835f
C52 B.n48 a_n637_n901# 0.00672f
C53 B.n49 a_n637_n901# 0.00835f
C54 B.n50 a_n637_n901# 0.01681f
C55 B.n51 a_n637_n901# 0.01153f
C56 B.n52 a_n637_n901# 0.00568f
C57 B.n53 a_n637_n901# 0.00568f
C58 B.n54 a_n637_n901# 0.00568f
C59 B.n55 a_n637_n901# 0.00568f
C60 B.n56 a_n637_n901# 0.00568f
C61 B.n57 a_n637_n901# 0.00568f
C62 B.n58 a_n637_n901# 0.00568f
C63 B.n59 a_n637_n901# 0.00568f
C64 B.n60 a_n637_n901# 0.00568f
C65 B.n61 a_n637_n901# 0.00568f
C66 B.n62 a_n637_n901# 0.00568f
C67 B.n63 a_n637_n901# 0.00568f
C68 B.n64 a_n637_n901# 0.00568f
C69 B.n65 a_n637_n901# 0.00568f
C70 B.n66 a_n637_n901# 0.00568f
C71 B.n67 a_n637_n901# 0.00568f
C72 B.n68 a_n637_n901# 0.00568f
C73 B.n69 a_n637_n901# 0.00568f
C74 B.n70 a_n637_n901# 0.00568f
C75 B.n71 a_n637_n901# 0.00568f
C76 B.n72 a_n637_n901# 0.00568f
C77 B.n73 a_n637_n901# 0.00568f
C78 B.n74 a_n637_n901# 0.00568f
C79 B.n75 a_n637_n901# 0.00568f
C80 B.n76 a_n637_n901# 0.00568f
C81 B.n77 a_n637_n901# 0.00568f
C82 B.n78 a_n637_n901# 0.00568f
C83 B.n79 a_n637_n901# 0.00568f
C84 B.n86 a_n637_n901# 0.0944f
C85 B.n88 a_n637_n901# 0.01681f
C86 B.n89 a_n637_n901# 0.01153f
C87 B.n90 a_n637_n901# 0.00558f
C88 B.n91 a_n637_n901# 0.02922f
C89 B.n92 a_n637_n901# 0.00558f
C90 B.n93 a_n637_n901# 0.02922f
C91 B.n94 a_n637_n901# 0.00672f
C92 B.n95 a_n637_n901# 0.00835f
C93 B.n96 a_n637_n901# 0.00672f
C94 B.n97 a_n637_n901# 0.00835f
C95 B.n98 a_n637_n901# 0.00672f
C96 B.n99 a_n637_n901# 0.01709f
C97 B.n100 a_n637_n901# 0.00835f
C98 B.n101 a_n637_n901# 0.00835f
C99 B.n102 a_n637_n901# 0.00835f
C100 B.n103 a_n637_n901# 0.01709f
C101 B.n104 a_n637_n901# 0.00835f
C102 B.n105 a_n637_n901# 0.00835f
C103 B.n106 a_n637_n901# 0.00835f
C104 B.n107 a_n637_n901# 0.18879f
C105 B.n108 a_n637_n901# 0.20012f
C106 B.n109 a_n637_n901# 0.01623f
C107 B.n110 a_n637_n901# 0.00558f
C108 B.n111 a_n637_n901# 0.17369f
C109 B.n112 a_n637_n901# 0.00835f
C110 B.n113 a_n637_n901# 0.00672f
C111 B.n114 a_n637_n901# 0.00835f
C112 B.n115 a_n637_n901# 0.00672f
C113 B.n116 a_n637_n901# 0.11044f
C114 B.n117 a_n637_n901# 0.00835f
C115 B.n118 a_n637_n901# 0.00672f
C116 B.n119 a_n637_n901# 0.1567f
C117 B.n120 a_n637_n901# 0.00835f
C118 B.n121 a_n637_n901# 0.00672f
C119 B.n122 a_n637_n901# 0.11044f
C120 B.n123 a_n637_n901# 0.00835f
C121 B.n124 a_n637_n901# 0.00672f
C122 B.n125 a_n637_n901# 0.18879f
C123 B.n126 a_n637_n901# 0.00835f
C124 B.n127 a_n637_n901# 0.00672f
C125 B.n128 a_n637_n901# 0.17369f
C126 B.n129 a_n637_n901# 0.00835f
C127 B.n130 a_n637_n901# 0.00672f
C128 B.n131 a_n637_n901# 0.20012f
C129 B.n132 a_n637_n901# 0.01623f
C130 B.n133 a_n637_n901# 0.01623f
C131 B.n134 a_n637_n901# 0.00558f
C132 B.n135 a_n637_n901# 0.00835f
C133 B.n136 a_n637_n901# 0.00835f
C134 B.n137 a_n637_n901# 0.00672f
C135 B.n138 a_n637_n901# 0.00835f
C136 B.n139 a_n637_n901# 0.00672f
C137 B.n140 a_n637_n901# 0.00835f
C138 B.n141 a_n637_n901# 0.00672f
C139 B.n142 a_n637_n901# 0.00835f
C140 B.n143 a_n637_n901# 0.00672f
C141 B.n144 a_n637_n901# 0.00835f
C142 B.n145 a_n637_n901# 0.00672f
C143 B.n146 a_n637_n901# 0.00835f
C144 B.n147 a_n637_n901# 0.00672f
C145 B.n148 a_n637_n901# 0.01623f
C146 B.n149 a_n637_n901# 0.00558f
C147 B.n150 a_n637_n901# 0.31151f
C148 B.n151 a_n637_n901# 0.0165f
C149 B.n152 a_n637_n901# 0.01051f
C150 B.n153 a_n637_n901# 0.00568f
C151 B.n154 a_n637_n901# 0.00568f
C152 B.n156 a_n637_n901# 0.00568f
C153 B.n157 a_n637_n901# 0.00568f
C154 B.n158 a_n637_n901# 0.00568f
C155 B.n159 a_n637_n901# 0.00568f
C156 B.n161 a_n637_n901# 0.00568f
C157 B.n162 a_n637_n901# 0.00568f
C158 B.n163 a_n637_n901# 0.00568f
C159 B.n164 a_n637_n901# 0.00568f
C160 B.n166 a_n637_n901# 0.00568f
C161 B.n167 a_n637_n901# 0.00568f
C162 B.n168 a_n637_n901# 0.00568f
C163 B.n169 a_n637_n901# 0.00568f
C164 B.n171 a_n637_n901# 0.00568f
C165 B.n172 a_n637_n901# 0.00568f
C166 B.n173 a_n637_n901# 0.00568f
C167 B.n174 a_n637_n901# 0.00568f
C168 B.n176 a_n637_n901# 0.00568f
C169 B.n177 a_n637_n901# 0.00568f
C170 B.n178 a_n637_n901# 0.00568f
C171 B.n179 a_n637_n901# 0.00568f
C172 B.n181 a_n637_n901# 0.00568f
C173 B.n182 a_n637_n901# 0.00568f
C174 B.n183 a_n637_n901# 0.00568f
C175 B.n184 a_n637_n901# 0.00568f
C176 B.n186 a_n637_n901# 0.00568f
C177 B.n187 a_n637_n901# 0.00568f
C178 B.n188 a_n637_n901# 0.00568f
C179 B.n189 a_n637_n901# 0.00568f
C180 B.n191 a_n637_n901# 0.00568f
C181 B.n192 a_n637_n901# 0.00568f
C182 B.n193 a_n637_n901# 0.00568f
C183 B.n194 a_n637_n901# 0.00568f
C184 B.n196 a_n637_n901# 0.00568f
C185 B.n197 a_n637_n901# 0.00568f
C186 B.n198 a_n637_n901# 0.00568f
C187 B.n199 a_n637_n901# 0.00568f
C188 B.n201 a_n637_n901# 0.00568f
C189 B.n202 a_n637_n901# 0.00568f
C190 B.n203 a_n637_n901# 0.00568f
C191 B.n204 a_n637_n901# 0.00568f
C192 B.n206 a_n637_n901# 0.0165f
C193 B.n207 a_n637_n901# 0.01051f
C194 B.n208 a_n637_n901# 0.0165f
C195 B.n209 a_n637_n901# 0.01051f
C196 B.n210 a_n637_n901# 0.00568f
C197 B.n211 a_n637_n901# 0.00568f
C198 B.n212 a_n637_n901# 0.00568f
C199 B.n213 a_n637_n901# 0.00568f
C200 B.n214 a_n637_n901# 0.00568f
C201 B.n215 a_n637_n901# 0.00568f
C202 B.n216 a_n637_n901# 0.00568f
C203 B.n217 a_n637_n901# 0.00568f
C204 B.n218 a_n637_n901# 0.00568f
C205 B.n219 a_n637_n901# 0.00568f
C206 B.n220 a_n637_n901# 0.00568f
C207 B.n221 a_n637_n901# 0.00568f
C208 B.n222 a_n637_n901# 0.00568f
C209 B.n223 a_n637_n901# 0.00568f
C210 B.n224 a_n637_n901# 0.00568f
C211 B.n225 a_n637_n901# 0.00568f
C212 B.n226 a_n637_n901# 0.00568f
C213 B.n227 a_n637_n901# 0.00568f
C214 B.n228 a_n637_n901# 0.00568f
C215 B.n229 a_n637_n901# 0.00568f
C216 B.n230 a_n637_n901# 0.00568f
C217 B.n231 a_n637_n901# 0.00568f
C218 B.n232 a_n637_n901# 0.00568f
C219 B.n233 a_n637_n901# 0.00568f
C220 B.n234 a_n637_n901# 0.00568f
C221 B.n235 a_n637_n901# 0.00568f
C222 B.n236 a_n637_n901# 0.00568f
C223 B.n237 a_n637_n901# 0.00568f
C224 B.n238 a_n637_n901# 0.00568f
C225 B.n239 a_n637_n901# 0.00568f
C226 B.n240 a_n637_n901# 0.00568f
C227 B.n241 a_n637_n901# 0.00568f
C228 B.n242 a_n637_n901# 0.00568f
C229 B.n243 a_n637_n901# 0.00568f
C230 B.n244 a_n637_n901# 0.00568f
C231 B.n245 a_n637_n901# 0.00568f
C232 B.n246 a_n637_n901# 0.00568f
C233 B.n247 a_n637_n901# 0.00568f
C234 B.n248 a_n637_n901# 0.00568f
C235 B.n249 a_n637_n901# 0.00568f
C236 B.n250 a_n637_n901# 0.00568f
C237 B.n251 a_n637_n901# 0.00568f
C238 B.n262 a_n637_n901# 0.31151f
C239 B.n264 a_n637_n901# 0.0165f
C240 B.n265 a_n637_n901# 0.02907f
C241 B.n266 a_n637_n901# 0.00835f
C242 B.n267 a_n637_n901# 0.00835f
C243 B.n268 a_n637_n901# 0.00835f
C244 B.n269 a_n637_n901# 0.00835f
C245 B.n270 a_n637_n901# 0.00835f
C246 B.n271 a_n637_n901# 0.00835f
C247 B.n272 a_n637_n901# 0.00835f
C248 B.n273 a_n637_n901# 0.00558f
C249 B.n274 a_n637_n901# 0.02907f
C250 B.n275 a_n637_n901# 0.02907f
C251 B.n276 a_n637_n901# 0.02907f
C252 B.n277 a_n637_n901# 0.00835f
C253 B.n278 a_n637_n901# 0.00835f
C254 B.n279 a_n637_n901# 0.00835f
C255 B.n280 a_n637_n901# 0.00835f
C256 B.n281 a_n637_n901# 0.00835f
C257 B.n282 a_n637_n901# 0.00835f
C258 B.n283 a_n637_n901# 0.00672f
C259 B.n284 a_n637_n901# 0.00835f
C260 B.n285 a_n637_n901# 0.01051f
C261 B.t0 a_n637_n901# 0.0944f
C262 B.t1 a_n637_n901# 0.0944f
C263 B.n286 a_n637_n901# 0.01709f
C264 B.n287 a_n637_n901# 0.00558f
C265 B.n288 a_n637_n901# 0.01709f
C266 B.n289 a_n637_n901# 0.00835f
C267 B.n290 a_n637_n901# 0.00266f
.ends
