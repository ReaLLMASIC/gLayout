.subckt corpus_c13 VSS IIN1 IOUT1 IB1
XM1_f0 IB1 IB1 VSS VSS sky130_fd_pr__nfet_01v8 w=0.5 l=0.45
XM1_f1 IB1 IB1 VSS VSS sky130_fd_pr__nfet_01v8 w=0.5 l=0.45
XM1_f2 IB1 IB1 VSS VSS sky130_fd_pr__nfet_01v8 w=0.5 l=0.45
XM2_f0 IIN1 IB1 net15 VSS sky130_fd_pr__nfet_01v8 w=0.5 l=0.45
XM2_f1 IIN1 IB1 net15 VSS sky130_fd_pr__nfet_01v8 w=0.5 l=0.45
XM2_f2 IIN1 IB1 net15 VSS sky130_fd_pr__nfet_01v8 w=0.5 l=0.45
XM2_f3 IIN1 IB1 net15 VSS sky130_fd_pr__nfet_01v8 w=0.5 l=0.45
XM2_f4 IIN1 IB1 net15 VSS sky130_fd_pr__nfet_01v8 w=0.5 l=0.45
XM2_f5 IIN1 IB1 net15 VSS sky130_fd_pr__nfet_01v8 w=0.5 l=0.45
XM2_f6 IIN1 IB1 net15 VSS sky130_fd_pr__nfet_01v8 w=0.5 l=0.45
XM2_f7 IIN1 IB1 net15 VSS sky130_fd_pr__nfet_01v8 w=0.5 l=0.45
XM2_f8 IIN1 IB1 net15 VSS sky130_fd_pr__nfet_01v8 w=0.5 l=0.45
XM2_f9 IIN1 IB1 net15 VSS sky130_fd_pr__nfet_01v8 w=0.5 l=0.45
XM2_f10 IIN1 IB1 net15 VSS sky130_fd_pr__nfet_01v8 w=0.5 l=0.45
XM2_f11 IIN1 IB1 net15 VSS sky130_fd_pr__nfet_01v8 w=0.5 l=0.45
XM3_f0 net15 IIN1 VSS VSS sky130_fd_pr__nfet_01v8 w=0.5 l=0.45
XM3_f1 net15 IIN1 VSS VSS sky130_fd_pr__nfet_01v8 w=0.5 l=0.45
XM3_f2 net15 IIN1 VSS VSS sky130_fd_pr__nfet_01v8 w=0.5 l=0.45
XM3_f3 net15 IIN1 VSS VSS sky130_fd_pr__nfet_01v8 w=0.5 l=0.45
XM3_f4 net15 IIN1 VSS VSS sky130_fd_pr__nfet_01v8 w=0.5 l=0.45
XM3_f5 net15 IIN1 VSS VSS sky130_fd_pr__nfet_01v8 w=0.5 l=0.45
XM3_f6 net15 IIN1 VSS VSS sky130_fd_pr__nfet_01v8 w=0.5 l=0.45
XM3_f7 net15 IIN1 VSS VSS sky130_fd_pr__nfet_01v8 w=0.5 l=0.45
XM3_f8 net15 IIN1 VSS VSS sky130_fd_pr__nfet_01v8 w=0.5 l=0.45
XM3_f9 net15 IIN1 VSS VSS sky130_fd_pr__nfet_01v8 w=0.5 l=0.45
XM3_f10 net15 IIN1 VSS VSS sky130_fd_pr__nfet_01v8 w=0.5 l=0.45
XM3_f11 net15 IIN1 VSS VSS sky130_fd_pr__nfet_01v8 w=0.5 l=0.45
XM4_f0 IOUT1 IB1 net14 VSS sky130_fd_pr__nfet_01v8 w=0.5 l=0.45
XM4_f1 IOUT1 IB1 net14 VSS sky130_fd_pr__nfet_01v8 w=0.5 l=0.45
XM4_f2 IOUT1 IB1 net14 VSS sky130_fd_pr__nfet_01v8 w=0.5 l=0.45
XM4_f3 IOUT1 IB1 net14 VSS sky130_fd_pr__nfet_01v8 w=0.5 l=0.45
XM4_f4 IOUT1 IB1 net14 VSS sky130_fd_pr__nfet_01v8 w=0.5 l=0.45
XM4_f5 IOUT1 IB1 net14 VSS sky130_fd_pr__nfet_01v8 w=0.5 l=0.45
XM4_f6 IOUT1 IB1 net14 VSS sky130_fd_pr__nfet_01v8 w=0.5 l=0.45
XM4_f7 IOUT1 IB1 net14 VSS sky130_fd_pr__nfet_01v8 w=0.5 l=0.45
XM4_f8 IOUT1 IB1 net14 VSS sky130_fd_pr__nfet_01v8 w=0.5 l=0.45
XM4_f9 IOUT1 IB1 net14 VSS sky130_fd_pr__nfet_01v8 w=0.5 l=0.45
XM4_f10 IOUT1 IB1 net14 VSS sky130_fd_pr__nfet_01v8 w=0.5 l=0.45
XM4_f11 IOUT1 IB1 net14 VSS sky130_fd_pr__nfet_01v8 w=0.5 l=0.45
XM5_f0 net14 IIN1 VSS VSS sky130_fd_pr__nfet_01v8 w=0.5 l=0.45
XM5_f1 net14 IIN1 VSS VSS sky130_fd_pr__nfet_01v8 w=0.5 l=0.45
XM5_f2 net14 IIN1 VSS VSS sky130_fd_pr__nfet_01v8 w=0.5 l=0.45
XM5_f3 net14 IIN1 VSS VSS sky130_fd_pr__nfet_01v8 w=0.5 l=0.45
XM5_f4 net14 IIN1 VSS VSS sky130_fd_pr__nfet_01v8 w=0.5 l=0.45
XM5_f5 net14 IIN1 VSS VSS sky130_fd_pr__nfet_01v8 w=0.5 l=0.45
XM5_f6 net14 IIN1 VSS VSS sky130_fd_pr__nfet_01v8 w=0.5 l=0.45
XM5_f7 net14 IIN1 VSS VSS sky130_fd_pr__nfet_01v8 w=0.5 l=0.45
XM5_f8 net14 IIN1 VSS VSS sky130_fd_pr__nfet_01v8 w=0.5 l=0.45
XM5_f9 net14 IIN1 VSS VSS sky130_fd_pr__nfet_01v8 w=0.5 l=0.45
XM5_f10 net14 IIN1 VSS VSS sky130_fd_pr__nfet_01v8 w=0.5 l=0.45
XM5_f11 net14 IIN1 VSS VSS sky130_fd_pr__nfet_01v8 w=0.5 l=0.45
.ends corpus_c13
