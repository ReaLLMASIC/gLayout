.subckt corpus_train_tg01 VDD VSS VIN1 VOUT1 VC1 VC2
XM1_f0 VOUT1 VC1 VIN1 VSS sky130_fd_pr__nfet_01v8 w=1 l=0.3
XM1_f1 VOUT1 VC1 VIN1 VSS sky130_fd_pr__nfet_01v8 w=1 l=0.3
XM1_f2 VOUT1 VC1 VIN1 VSS sky130_fd_pr__nfet_01v8 w=1 l=0.3
XM1_f3 VOUT1 VC1 VIN1 VSS sky130_fd_pr__nfet_01v8 w=1 l=0.3
XM1_f4 VOUT1 VC1 VIN1 VSS sky130_fd_pr__nfet_01v8 w=1 l=0.3
XM1_f5 VOUT1 VC1 VIN1 VSS sky130_fd_pr__nfet_01v8 w=1 l=0.3
XM1_f6 VOUT1 VC1 VIN1 VSS sky130_fd_pr__nfet_01v8 w=1 l=0.3
XM1_f7 VOUT1 VC1 VIN1 VSS sky130_fd_pr__nfet_01v8 w=1 l=0.3
XM1_f8 VOUT1 VC1 VIN1 VSS sky130_fd_pr__nfet_01v8 w=1 l=0.3
XM1_f9 VOUT1 VC1 VIN1 VSS sky130_fd_pr__nfet_01v8 w=1 l=0.3
XM1_f10 VOUT1 VC1 VIN1 VSS sky130_fd_pr__nfet_01v8 w=1 l=0.3
XM1_f11 VOUT1 VC1 VIN1 VSS sky130_fd_pr__nfet_01v8 w=1 l=0.3
XM1_f12 VOUT1 VC1 VIN1 VSS sky130_fd_pr__nfet_01v8 w=1 l=0.3
XM1_f13 VOUT1 VC1 VIN1 VSS sky130_fd_pr__nfet_01v8 w=1 l=0.3
XM1_f14 VOUT1 VC1 VIN1 VSS sky130_fd_pr__nfet_01v8 w=1 l=0.3
XM1_f15 VOUT1 VC1 VIN1 VSS sky130_fd_pr__nfet_01v8 w=1 l=0.3
XM2_f0 VOUT1 VC2 VIN1 VDD sky130_fd_pr__pfet_01v8 w=1 l=0.3
XM2_f1 VOUT1 VC2 VIN1 VDD sky130_fd_pr__pfet_01v8 w=1 l=0.3
XM2_f2 VOUT1 VC2 VIN1 VDD sky130_fd_pr__pfet_01v8 w=1 l=0.3
XM2_f3 VOUT1 VC2 VIN1 VDD sky130_fd_pr__pfet_01v8 w=1 l=0.3
XM2_f4 VOUT1 VC2 VIN1 VDD sky130_fd_pr__pfet_01v8 w=1 l=0.3
XM2_f5 VOUT1 VC2 VIN1 VDD sky130_fd_pr__pfet_01v8 w=1 l=0.3
XM2_f6 VOUT1 VC2 VIN1 VDD sky130_fd_pr__pfet_01v8 w=1 l=0.3
XM2_f7 VOUT1 VC2 VIN1 VDD sky130_fd_pr__pfet_01v8 w=1 l=0.3
XM2_f8 VOUT1 VC2 VIN1 VDD sky130_fd_pr__pfet_01v8 w=1 l=0.3
XM2_f9 VOUT1 VC2 VIN1 VDD sky130_fd_pr__pfet_01v8 w=1 l=0.3
XM2_f10 VOUT1 VC2 VIN1 VDD sky130_fd_pr__pfet_01v8 w=1 l=0.3
XM2_f11 VOUT1 VC2 VIN1 VDD sky130_fd_pr__pfet_01v8 w=1 l=0.3
XM2_f12 VOUT1 VC2 VIN1 VDD sky130_fd_pr__pfet_01v8 w=1 l=0.3
XM2_f13 VOUT1 VC2 VIN1 VDD sky130_fd_pr__pfet_01v8 w=1 l=0.3
XM2_f14 VOUT1 VC2 VIN1 VDD sky130_fd_pr__pfet_01v8 w=1 l=0.3
XM2_f15 VOUT1 VC2 VIN1 VDD sky130_fd_pr__pfet_01v8 w=1 l=0.3
XM2_f16 VOUT1 VC2 VIN1 VDD sky130_fd_pr__pfet_01v8 w=1 l=0.3
XM2_f17 VOUT1 VC2 VIN1 VDD sky130_fd_pr__pfet_01v8 w=1 l=0.3
XM2_f18 VOUT1 VC2 VIN1 VDD sky130_fd_pr__pfet_01v8 w=1 l=0.3
XM2_f19 VOUT1 VC2 VIN1 VDD sky130_fd_pr__pfet_01v8 w=1 l=0.3
XM2_f20 VOUT1 VC2 VIN1 VDD sky130_fd_pr__pfet_01v8 w=1 l=0.3
XM2_f21 VOUT1 VC2 VIN1 VDD sky130_fd_pr__pfet_01v8 w=1 l=0.3
XM2_f22 VOUT1 VC2 VIN1 VDD sky130_fd_pr__pfet_01v8 w=1 l=0.3
XM2_f23 VOUT1 VC2 VIN1 VDD sky130_fd_pr__pfet_01v8 w=1 l=0.3
XM2_f24 VOUT1 VC2 VIN1 VDD sky130_fd_pr__pfet_01v8 w=1 l=0.3
XM2_f25 VOUT1 VC2 VIN1 VDD sky130_fd_pr__pfet_01v8 w=1 l=0.3
XM2_f26 VOUT1 VC2 VIN1 VDD sky130_fd_pr__pfet_01v8 w=1 l=0.3
XM2_f27 VOUT1 VC2 VIN1 VDD sky130_fd_pr__pfet_01v8 w=1 l=0.3
XM2_f28 VOUT1 VC2 VIN1 VDD sky130_fd_pr__pfet_01v8 w=1 l=0.3
XM2_f29 VOUT1 VC2 VIN1 VDD sky130_fd_pr__pfet_01v8 w=1 l=0.3
XM2_f30 VOUT1 VC2 VIN1 VDD sky130_fd_pr__pfet_01v8 w=1 l=0.3
XM2_f31 VOUT1 VC2 VIN1 VDD sky130_fd_pr__pfet_01v8 w=1 l=0.3
.ends corpus_train_tg01
