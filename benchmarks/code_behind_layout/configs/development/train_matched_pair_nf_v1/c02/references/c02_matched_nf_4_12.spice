.subckt train_pair_nf_c02 VSS IIN1 IOUT1
XM1_f0 IIN1 IIN1 net6 VSS sky130_fd_pr__nfet_01v8 w=0.5 l=0.6
XM1_f1 IIN1 IIN1 net6 VSS sky130_fd_pr__nfet_01v8 w=0.5 l=0.6
XM1_f2 IIN1 IIN1 net6 VSS sky130_fd_pr__nfet_01v8 w=0.5 l=0.6
XM1_f3 IIN1 IIN1 net6 VSS sky130_fd_pr__nfet_01v8 w=0.5 l=0.6
XM2_f0 net6 net6 VSS VSS sky130_fd_pr__nfet_01v8 w=0.5 l=0.6
XM2_f1 net6 net6 VSS VSS sky130_fd_pr__nfet_01v8 w=0.5 l=0.6
XM2_f2 net6 net6 VSS VSS sky130_fd_pr__nfet_01v8 w=0.5 l=0.6
XM2_f3 net6 net6 VSS VSS sky130_fd_pr__nfet_01v8 w=0.5 l=0.6
XM2_f4 net6 net6 VSS VSS sky130_fd_pr__nfet_01v8 w=0.5 l=0.6
XM2_f5 net6 net6 VSS VSS sky130_fd_pr__nfet_01v8 w=0.5 l=0.6
XM2_f6 net6 net6 VSS VSS sky130_fd_pr__nfet_01v8 w=0.5 l=0.6
XM2_f7 net6 net6 VSS VSS sky130_fd_pr__nfet_01v8 w=0.5 l=0.6
XM2_f8 net6 net6 VSS VSS sky130_fd_pr__nfet_01v8 w=0.5 l=0.6
XM2_f9 net6 net6 VSS VSS sky130_fd_pr__nfet_01v8 w=0.5 l=0.6
XM2_f10 net6 net6 VSS VSS sky130_fd_pr__nfet_01v8 w=0.5 l=0.6
XM2_f11 net6 net6 VSS VSS sky130_fd_pr__nfet_01v8 w=0.5 l=0.6
XM3_f0 IOUT1 IIN1 net12 VSS sky130_fd_pr__nfet_01v8 w=0.5 l=0.6
XM3_f1 IOUT1 IIN1 net12 VSS sky130_fd_pr__nfet_01v8 w=0.5 l=0.6
XM3_f2 IOUT1 IIN1 net12 VSS sky130_fd_pr__nfet_01v8 w=0.5 l=0.6
XM3_f3 IOUT1 IIN1 net12 VSS sky130_fd_pr__nfet_01v8 w=0.5 l=0.6
XM4_f0 net12 net6 VSS VSS sky130_fd_pr__nfet_01v8 w=0.5 l=0.6
XM4_f1 net12 net6 VSS VSS sky130_fd_pr__nfet_01v8 w=0.5 l=0.6
XM4_f2 net12 net6 VSS VSS sky130_fd_pr__nfet_01v8 w=0.5 l=0.6
XM4_f3 net12 net6 VSS VSS sky130_fd_pr__nfet_01v8 w=0.5 l=0.6
XM4_f4 net12 net6 VSS VSS sky130_fd_pr__nfet_01v8 w=0.5 l=0.6
XM4_f5 net12 net6 VSS VSS sky130_fd_pr__nfet_01v8 w=0.5 l=0.6
XM4_f6 net12 net6 VSS VSS sky130_fd_pr__nfet_01v8 w=0.5 l=0.6
XM4_f7 net12 net6 VSS VSS sky130_fd_pr__nfet_01v8 w=0.5 l=0.6
XM4_f8 net12 net6 VSS VSS sky130_fd_pr__nfet_01v8 w=0.5 l=0.6
XM4_f9 net12 net6 VSS VSS sky130_fd_pr__nfet_01v8 w=0.5 l=0.6
XM4_f10 net12 net6 VSS VSS sky130_fd_pr__nfet_01v8 w=0.5 l=0.6
XM4_f11 net12 net6 VSS VSS sky130_fd_pr__nfet_01v8 w=0.5 l=0.6
.ends train_pair_nf_c02
