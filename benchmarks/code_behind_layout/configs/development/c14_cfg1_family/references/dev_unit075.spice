.subckt corpus_c14 VSS IIN1 IOUT1 IREF1
XM1_f0 IIN1 IIN1 VSS VSS sky130_fd_pr__nfet_01v8 w=0.75 l=0.6
XM1_f1 IIN1 IIN1 VSS VSS sky130_fd_pr__nfet_01v8 w=0.75 l=0.6
XM1_f2 IIN1 IIN1 VSS VSS sky130_fd_pr__nfet_01v8 w=0.75 l=0.6
XM1_f3 IIN1 IIN1 VSS VSS sky130_fd_pr__nfet_01v8 w=0.75 l=0.6
XM1_f4 IIN1 IIN1 VSS VSS sky130_fd_pr__nfet_01v8 w=0.75 l=0.6
XM1_f5 IIN1 IIN1 VSS VSS sky130_fd_pr__nfet_01v8 w=0.75 l=0.6
XM2_f0 net11 IIN1 VSS VSS sky130_fd_pr__nfet_01v8 w=0.75 l=0.6
XM2_f1 net11 IIN1 VSS VSS sky130_fd_pr__nfet_01v8 w=0.75 l=0.6
XM2_f2 net11 IIN1 VSS VSS sky130_fd_pr__nfet_01v8 w=0.75 l=0.6
XM2_f3 net11 IIN1 VSS VSS sky130_fd_pr__nfet_01v8 w=0.75 l=0.6
XM2_f4 net11 IIN1 VSS VSS sky130_fd_pr__nfet_01v8 w=0.75 l=0.6
XM2_f5 net11 IIN1 VSS VSS sky130_fd_pr__nfet_01v8 w=0.75 l=0.6
XM3_f0 IREF1 net11 VSS VSS sky130_fd_pr__nfet_01v8 w=0.75 l=0.6
XM3_f1 IREF1 net11 VSS VSS sky130_fd_pr__nfet_01v8 w=0.75 l=0.6
XM3_f2 IREF1 net11 VSS VSS sky130_fd_pr__nfet_01v8 w=0.75 l=0.6
XM3_f3 IREF1 net11 VSS VSS sky130_fd_pr__nfet_01v8 w=0.75 l=0.6
XM4_f0 IOUT1 IREF1 net11 VSS sky130_fd_pr__nfet_01v8 w=0.75 l=0.6
XM4_f1 IOUT1 IREF1 net11 VSS sky130_fd_pr__nfet_01v8 w=0.75 l=0.6
XM4_f2 IOUT1 IREF1 net11 VSS sky130_fd_pr__nfet_01v8 w=0.75 l=0.6
XM4_f3 IOUT1 IREF1 net11 VSS sky130_fd_pr__nfet_01v8 w=0.75 l=0.6
XM4_f4 IOUT1 IREF1 net11 VSS sky130_fd_pr__nfet_01v8 w=0.75 l=0.6
XM4_f5 IOUT1 IREF1 net11 VSS sky130_fd_pr__nfet_01v8 w=0.75 l=0.6
.ends corpus_c14
