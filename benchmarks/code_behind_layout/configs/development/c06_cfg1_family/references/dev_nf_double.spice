.subckt corpus_c06 VDD VSS VIN1 VOUT1 VB1 VB2 VB3
XM1_f0 VOUT1 VB2 net10 VDD sky130_fd_pr__pfet_01v8 w=0.5 l=0.3
XM1_f1 VOUT1 VB2 net10 VDD sky130_fd_pr__pfet_01v8 w=0.5 l=0.3
XM1_f2 VOUT1 VB2 net10 VDD sky130_fd_pr__pfet_01v8 w=0.5 l=0.3
XM1_f3 VOUT1 VB2 net10 VDD sky130_fd_pr__pfet_01v8 w=0.5 l=0.3
XM1_f4 VOUT1 VB2 net10 VDD sky130_fd_pr__pfet_01v8 w=0.5 l=0.3
XM1_f5 VOUT1 VB2 net10 VDD sky130_fd_pr__pfet_01v8 w=0.5 l=0.3
XM1_f6 VOUT1 VB2 net10 VDD sky130_fd_pr__pfet_01v8 w=0.5 l=0.3
XM1_f7 VOUT1 VB2 net10 VDD sky130_fd_pr__pfet_01v8 w=0.5 l=0.3
XM1_f8 VOUT1 VB2 net10 VDD sky130_fd_pr__pfet_01v8 w=0.5 l=0.3
XM1_f9 VOUT1 VB2 net10 VDD sky130_fd_pr__pfet_01v8 w=0.5 l=0.3
XM1_f10 VOUT1 VB2 net10 VDD sky130_fd_pr__pfet_01v8 w=0.5 l=0.3
XM1_f11 VOUT1 VB2 net10 VDD sky130_fd_pr__pfet_01v8 w=0.5 l=0.3
XM1_f12 VOUT1 VB2 net10 VDD sky130_fd_pr__pfet_01v8 w=0.5 l=0.3
XM1_f13 VOUT1 VB2 net10 VDD sky130_fd_pr__pfet_01v8 w=0.5 l=0.3
XM1_f14 VOUT1 VB2 net10 VDD sky130_fd_pr__pfet_01v8 w=0.5 l=0.3
XM1_f15 VOUT1 VB2 net10 VDD sky130_fd_pr__pfet_01v8 w=0.5 l=0.3
XM1_f16 VOUT1 VB2 net10 VDD sky130_fd_pr__pfet_01v8 w=0.5 l=0.3
XM1_f17 VOUT1 VB2 net10 VDD sky130_fd_pr__pfet_01v8 w=0.5 l=0.3
XM1_f18 VOUT1 VB2 net10 VDD sky130_fd_pr__pfet_01v8 w=0.5 l=0.3
XM1_f19 VOUT1 VB2 net10 VDD sky130_fd_pr__pfet_01v8 w=0.5 l=0.3
XM1_f20 VOUT1 VB2 net10 VDD sky130_fd_pr__pfet_01v8 w=0.5 l=0.3
XM1_f21 VOUT1 VB2 net10 VDD sky130_fd_pr__pfet_01v8 w=0.5 l=0.3
XM1_f22 VOUT1 VB2 net10 VDD sky130_fd_pr__pfet_01v8 w=0.5 l=0.3
XM1_f23 VOUT1 VB2 net10 VDD sky130_fd_pr__pfet_01v8 w=0.5 l=0.3
XM2_f0 net10 VB3 VDD VDD sky130_fd_pr__pfet_01v8 w=0.5 l=0.3
XM2_f1 net10 VB3 VDD VDD sky130_fd_pr__pfet_01v8 w=0.5 l=0.3
XM2_f2 net10 VB3 VDD VDD sky130_fd_pr__pfet_01v8 w=0.5 l=0.3
XM2_f3 net10 VB3 VDD VDD sky130_fd_pr__pfet_01v8 w=0.5 l=0.3
XM2_f4 net10 VB3 VDD VDD sky130_fd_pr__pfet_01v8 w=0.5 l=0.3
XM2_f5 net10 VB3 VDD VDD sky130_fd_pr__pfet_01v8 w=0.5 l=0.3
XM2_f6 net10 VB3 VDD VDD sky130_fd_pr__pfet_01v8 w=0.5 l=0.3
XM2_f7 net10 VB3 VDD VDD sky130_fd_pr__pfet_01v8 w=0.5 l=0.3
XM2_f8 net10 VB3 VDD VDD sky130_fd_pr__pfet_01v8 w=0.5 l=0.3
XM2_f9 net10 VB3 VDD VDD sky130_fd_pr__pfet_01v8 w=0.5 l=0.3
XM2_f10 net10 VB3 VDD VDD sky130_fd_pr__pfet_01v8 w=0.5 l=0.3
XM2_f11 net10 VB3 VDD VDD sky130_fd_pr__pfet_01v8 w=0.5 l=0.3
XM2_f12 net10 VB3 VDD VDD sky130_fd_pr__pfet_01v8 w=0.5 l=0.3
XM2_f13 net10 VB3 VDD VDD sky130_fd_pr__pfet_01v8 w=0.5 l=0.3
XM2_f14 net10 VB3 VDD VDD sky130_fd_pr__pfet_01v8 w=0.5 l=0.3
XM2_f15 net10 VB3 VDD VDD sky130_fd_pr__pfet_01v8 w=0.5 l=0.3
XM2_f16 net10 VB3 VDD VDD sky130_fd_pr__pfet_01v8 w=0.5 l=0.3
XM2_f17 net10 VB3 VDD VDD sky130_fd_pr__pfet_01v8 w=0.5 l=0.3
XM2_f18 net10 VB3 VDD VDD sky130_fd_pr__pfet_01v8 w=0.5 l=0.3
XM2_f19 net10 VB3 VDD VDD sky130_fd_pr__pfet_01v8 w=0.5 l=0.3
XM2_f20 net10 VB3 VDD VDD sky130_fd_pr__pfet_01v8 w=0.5 l=0.3
XM2_f21 net10 VB3 VDD VDD sky130_fd_pr__pfet_01v8 w=0.5 l=0.3
XM2_f22 net10 VB3 VDD VDD sky130_fd_pr__pfet_01v8 w=0.5 l=0.3
XM2_f23 net10 VB3 VDD VDD sky130_fd_pr__pfet_01v8 w=0.5 l=0.3
XM3_f0 net9 VIN1 VSS VSS sky130_fd_pr__nfet_01v8 w=0.5 l=0.3
XM3_f1 net9 VIN1 VSS VSS sky130_fd_pr__nfet_01v8 w=0.5 l=0.3
XM3_f2 net9 VIN1 VSS VSS sky130_fd_pr__nfet_01v8 w=0.5 l=0.3
XM3_f3 net9 VIN1 VSS VSS sky130_fd_pr__nfet_01v8 w=0.5 l=0.3
XM3_f4 net9 VIN1 VSS VSS sky130_fd_pr__nfet_01v8 w=0.5 l=0.3
XM3_f5 net9 VIN1 VSS VSS sky130_fd_pr__nfet_01v8 w=0.5 l=0.3
XM3_f6 net9 VIN1 VSS VSS sky130_fd_pr__nfet_01v8 w=0.5 l=0.3
XM3_f7 net9 VIN1 VSS VSS sky130_fd_pr__nfet_01v8 w=0.5 l=0.3
XM3_f8 net9 VIN1 VSS VSS sky130_fd_pr__nfet_01v8 w=0.5 l=0.3
XM3_f9 net9 VIN1 VSS VSS sky130_fd_pr__nfet_01v8 w=0.5 l=0.3
XM3_f10 net9 VIN1 VSS VSS sky130_fd_pr__nfet_01v8 w=0.5 l=0.3
XM3_f11 net9 VIN1 VSS VSS sky130_fd_pr__nfet_01v8 w=0.5 l=0.3
XM4_f0 VOUT1 VB1 net9 VSS sky130_fd_pr__nfet_01v8 w=0.5 l=0.3
XM4_f1 VOUT1 VB1 net9 VSS sky130_fd_pr__nfet_01v8 w=0.5 l=0.3
XM4_f2 VOUT1 VB1 net9 VSS sky130_fd_pr__nfet_01v8 w=0.5 l=0.3
XM4_f3 VOUT1 VB1 net9 VSS sky130_fd_pr__nfet_01v8 w=0.5 l=0.3
XM4_f4 VOUT1 VB1 net9 VSS sky130_fd_pr__nfet_01v8 w=0.5 l=0.3
XM4_f5 VOUT1 VB1 net9 VSS sky130_fd_pr__nfet_01v8 w=0.5 l=0.3
XM4_f6 VOUT1 VB1 net9 VSS sky130_fd_pr__nfet_01v8 w=0.5 l=0.3
XM4_f7 VOUT1 VB1 net9 VSS sky130_fd_pr__nfet_01v8 w=0.5 l=0.3
XM4_f8 VOUT1 VB1 net9 VSS sky130_fd_pr__nfet_01v8 w=0.5 l=0.3
XM4_f9 VOUT1 VB1 net9 VSS sky130_fd_pr__nfet_01v8 w=0.5 l=0.3
XM4_f10 VOUT1 VB1 net9 VSS sky130_fd_pr__nfet_01v8 w=0.5 l=0.3
XM4_f11 VOUT1 VB1 net9 VSS sky130_fd_pr__nfet_01v8 w=0.5 l=0.3
.ends corpus_c06
