.subckt corpus_c12 VDD VSS VIN1 VOUT1
XM1_f0 VOUT1 VIN1 VSS VSS sky130_fd_pr__nfet_01v8 w=0.5 l=0.225
XM1_f1 VOUT1 VIN1 VSS VSS sky130_fd_pr__nfet_01v8 w=0.5 l=0.225
XM1_f2 VOUT1 VIN1 VSS VSS sky130_fd_pr__nfet_01v8 w=0.5 l=0.225
XM1_f3 VOUT1 VIN1 VSS VSS sky130_fd_pr__nfet_01v8 w=0.5 l=0.225
XM2_f0 VOUT1 VIN1 VDD VDD sky130_fd_pr__pfet_01v8 w=0.5 l=0.225
XM2_f1 VOUT1 VIN1 VDD VDD sky130_fd_pr__pfet_01v8 w=0.5 l=0.225
XM2_f2 VOUT1 VIN1 VDD VDD sky130_fd_pr__pfet_01v8 w=0.5 l=0.225
XM2_f3 VOUT1 VIN1 VDD VDD sky130_fd_pr__pfet_01v8 w=0.5 l=0.225
XM2_f4 VOUT1 VIN1 VDD VDD sky130_fd_pr__pfet_01v8 w=0.5 l=0.225
XM2_f5 VOUT1 VIN1 VDD VDD sky130_fd_pr__pfet_01v8 w=0.5 l=0.225
XM2_f6 VOUT1 VIN1 VDD VDD sky130_fd_pr__pfet_01v8 w=0.5 l=0.225
XM2_f7 VOUT1 VIN1 VDD VDD sky130_fd_pr__pfet_01v8 w=0.5 l=0.225
.ends corpus_c12
