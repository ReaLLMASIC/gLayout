.subckt corpus_c08 VDD VSS VIN1 VIN2 VOUT1 VB1
XM1_f0 net22 VIN1 net23 VSS sky130_fd_pr__nfet_01v8 w=0.5 l=0.3
XM1_f1 net22 VIN1 net23 VSS sky130_fd_pr__nfet_01v8 w=0.5 l=0.3
XM1_f2 net22 VIN1 net23 VSS sky130_fd_pr__nfet_01v8 w=0.5 l=0.3
XM1_f3 net22 VIN1 net23 VSS sky130_fd_pr__nfet_01v8 w=0.5 l=0.3
XM2_f0 VOUT1 VIN2 net23 VSS sky130_fd_pr__nfet_01v8 w=0.5 l=0.3
XM2_f1 VOUT1 VIN2 net23 VSS sky130_fd_pr__nfet_01v8 w=0.5 l=0.3
XM2_f2 VOUT1 VIN2 net23 VSS sky130_fd_pr__nfet_01v8 w=0.5 l=0.3
XM2_f3 VOUT1 VIN2 net23 VSS sky130_fd_pr__nfet_01v8 w=0.5 l=0.3
XM3_f0 net23 VB1 VSS VSS sky130_fd_pr__nfet_01v8 w=0.5 l=0.3
XM3_f1 net23 VB1 VSS VSS sky130_fd_pr__nfet_01v8 w=0.5 l=0.3
XM3_f2 net23 VB1 VSS VSS sky130_fd_pr__nfet_01v8 w=0.5 l=0.3
XM3_f3 net23 VB1 VSS VSS sky130_fd_pr__nfet_01v8 w=0.5 l=0.3
XM4_f0 net22 net22 VDD VDD sky130_fd_pr__pfet_01v8 w=0.5 l=0.3
XM4_f1 net22 net22 VDD VDD sky130_fd_pr__pfet_01v8 w=0.5 l=0.3
XM5_f0 VOUT1 net22 VDD VDD sky130_fd_pr__pfet_01v8 w=0.5 l=0.3
XM5_f1 VOUT1 net22 VDD VDD sky130_fd_pr__pfet_01v8 w=0.5 l=0.3
.ends corpus_c08
