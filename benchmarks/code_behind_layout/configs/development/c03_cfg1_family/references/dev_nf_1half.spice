.subckt corpus_c03 VSS IIN1 IOUT1
XM1_f0 IIN1 Y VSS VSS sky130_fd_pr__nfet_01v8 w=0.5 l=1.2
XM1_f1 IIN1 Y VSS VSS sky130_fd_pr__nfet_01v8 w=0.5 l=1.2
XM1_f2 IIN1 Y VSS VSS sky130_fd_pr__nfet_01v8 w=0.5 l=1.2
XM1_f3 IIN1 Y VSS VSS sky130_fd_pr__nfet_01v8 w=0.5 l=1.2
XM1_f4 IIN1 Y VSS VSS sky130_fd_pr__nfet_01v8 w=0.5 l=1.2
XM1_f5 IIN1 Y VSS VSS sky130_fd_pr__nfet_01v8 w=0.5 l=1.2
XM1_f6 IIN1 Y VSS VSS sky130_fd_pr__nfet_01v8 w=0.5 l=1.2
XM1_f7 IIN1 Y VSS VSS sky130_fd_pr__nfet_01v8 w=0.5 l=1.2
XM1_f8 IIN1 Y VSS VSS sky130_fd_pr__nfet_01v8 w=0.5 l=1.2
XM1_f9 IIN1 Y VSS VSS sky130_fd_pr__nfet_01v8 w=0.5 l=1.2
XM1_f10 IIN1 Y VSS VSS sky130_fd_pr__nfet_01v8 w=0.5 l=1.2
XM1_f11 IIN1 Y VSS VSS sky130_fd_pr__nfet_01v8 w=0.5 l=1.2
XM1_f12 IIN1 Y VSS VSS sky130_fd_pr__nfet_01v8 w=0.5 l=1.2
XM1_f13 IIN1 Y VSS VSS sky130_fd_pr__nfet_01v8 w=0.5 l=1.2
XM1_f14 IIN1 Y VSS VSS sky130_fd_pr__nfet_01v8 w=0.5 l=1.2
XM1_f15 IIN1 Y VSS VSS sky130_fd_pr__nfet_01v8 w=0.5 l=1.2
XM1_f16 IIN1 Y VSS VSS sky130_fd_pr__nfet_01v8 w=0.5 l=1.2
XM1_f17 IIN1 Y VSS VSS sky130_fd_pr__nfet_01v8 w=0.5 l=1.2
XM2_f0 Y Y VSS VSS sky130_fd_pr__nfet_01v8 w=0.5 l=1.2
XM2_f1 Y Y VSS VSS sky130_fd_pr__nfet_01v8 w=0.5 l=1.2
XM2_f2 Y Y VSS VSS sky130_fd_pr__nfet_01v8 w=0.5 l=1.2
XM2_f3 Y Y VSS VSS sky130_fd_pr__nfet_01v8 w=0.5 l=1.2
XM2_f4 Y Y VSS VSS sky130_fd_pr__nfet_01v8 w=0.5 l=1.2
XM2_f5 Y Y VSS VSS sky130_fd_pr__nfet_01v8 w=0.5 l=1.2
XM2_f6 Y Y VSS VSS sky130_fd_pr__nfet_01v8 w=0.5 l=1.2
XM2_f7 Y Y VSS VSS sky130_fd_pr__nfet_01v8 w=0.5 l=1.2
XM2_f8 Y Y VSS VSS sky130_fd_pr__nfet_01v8 w=0.5 l=1.2
XM2_f9 Y Y VSS VSS sky130_fd_pr__nfet_01v8 w=0.5 l=1.2
XM2_f10 Y Y VSS VSS sky130_fd_pr__nfet_01v8 w=0.5 l=1.2
XM2_f11 Y Y VSS VSS sky130_fd_pr__nfet_01v8 w=0.5 l=1.2
XM2_f12 Y Y VSS VSS sky130_fd_pr__nfet_01v8 w=0.5 l=1.2
XM2_f13 Y Y VSS VSS sky130_fd_pr__nfet_01v8 w=0.5 l=1.2
XM2_f14 Y Y VSS VSS sky130_fd_pr__nfet_01v8 w=0.5 l=1.2
XM2_f15 Y Y VSS VSS sky130_fd_pr__nfet_01v8 w=0.5 l=1.2
XM2_f16 Y Y VSS VSS sky130_fd_pr__nfet_01v8 w=0.5 l=1.2
XM2_f17 Y Y VSS VSS sky130_fd_pr__nfet_01v8 w=0.5 l=1.2
XM3_f0 IOUT1 IIN1 Y VSS sky130_fd_pr__nfet_01v8 w=0.5 l=1.2
XM3_f1 IOUT1 IIN1 Y VSS sky130_fd_pr__nfet_01v8 w=0.5 l=1.2
XM3_f2 IOUT1 IIN1 Y VSS sky130_fd_pr__nfet_01v8 w=0.5 l=1.2
XM3_f3 IOUT1 IIN1 Y VSS sky130_fd_pr__nfet_01v8 w=0.5 l=1.2
XM3_f4 IOUT1 IIN1 Y VSS sky130_fd_pr__nfet_01v8 w=0.5 l=1.2
XM3_f5 IOUT1 IIN1 Y VSS sky130_fd_pr__nfet_01v8 w=0.5 l=1.2
XM3_f6 IOUT1 IIN1 Y VSS sky130_fd_pr__nfet_01v8 w=0.5 l=1.2
XM3_f7 IOUT1 IIN1 Y VSS sky130_fd_pr__nfet_01v8 w=0.5 l=1.2
XM3_f8 IOUT1 IIN1 Y VSS sky130_fd_pr__nfet_01v8 w=0.5 l=1.2
XM3_f9 IOUT1 IIN1 Y VSS sky130_fd_pr__nfet_01v8 w=0.5 l=1.2
XM3_f10 IOUT1 IIN1 Y VSS sky130_fd_pr__nfet_01v8 w=0.5 l=1.2
XM3_f11 IOUT1 IIN1 Y VSS sky130_fd_pr__nfet_01v8 w=0.5 l=1.2
XM3_f12 IOUT1 IIN1 Y VSS sky130_fd_pr__nfet_01v8 w=0.5 l=1.2
XM3_f13 IOUT1 IIN1 Y VSS sky130_fd_pr__nfet_01v8 w=0.5 l=1.2
XM3_f14 IOUT1 IIN1 Y VSS sky130_fd_pr__nfet_01v8 w=0.5 l=1.2
XM3_f15 IOUT1 IIN1 Y VSS sky130_fd_pr__nfet_01v8 w=0.5 l=1.2
XM3_f16 IOUT1 IIN1 Y VSS sky130_fd_pr__nfet_01v8 w=0.5 l=1.2
XM3_f17 IOUT1 IIN1 Y VSS sky130_fd_pr__nfet_01v8 w=0.5 l=1.2
.ends corpus_c03
