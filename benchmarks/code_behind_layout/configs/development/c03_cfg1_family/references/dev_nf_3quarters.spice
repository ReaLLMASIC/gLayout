.subckt corpus_c03 VSS IIN1 IOUT1
XM1_f0 IIN1 Y VSS VSS sky130_fd_pr__nfet_01v8 w=0.5 l=1.2
XM1_f1 IIN1 Y VSS VSS sky130_fd_pr__nfet_01v8 w=0.5 l=1.2
XM1_f2 IIN1 Y VSS VSS sky130_fd_pr__nfet_01v8 w=0.5 l=1.2
XM1_f3 IIN1 Y VSS VSS sky130_fd_pr__nfet_01v8 w=0.5 l=1.2
XM1_f4 IIN1 Y VSS VSS sky130_fd_pr__nfet_01v8 w=0.5 l=1.2
XM1_f5 IIN1 Y VSS VSS sky130_fd_pr__nfet_01v8 w=0.5 l=1.2
XM1_f6 IIN1 Y VSS VSS sky130_fd_pr__nfet_01v8 w=0.5 l=1.2
XM1_f7 IIN1 Y VSS VSS sky130_fd_pr__nfet_01v8 w=0.5 l=1.2
XM1_f8 IIN1 Y VSS VSS sky130_fd_pr__nfet_01v8 w=0.5 l=1.2
XM2_f0 Y Y VSS VSS sky130_fd_pr__nfet_01v8 w=0.5 l=1.2
XM2_f1 Y Y VSS VSS sky130_fd_pr__nfet_01v8 w=0.5 l=1.2
XM2_f2 Y Y VSS VSS sky130_fd_pr__nfet_01v8 w=0.5 l=1.2
XM2_f3 Y Y VSS VSS sky130_fd_pr__nfet_01v8 w=0.5 l=1.2
XM2_f4 Y Y VSS VSS sky130_fd_pr__nfet_01v8 w=0.5 l=1.2
XM2_f5 Y Y VSS VSS sky130_fd_pr__nfet_01v8 w=0.5 l=1.2
XM2_f6 Y Y VSS VSS sky130_fd_pr__nfet_01v8 w=0.5 l=1.2
XM2_f7 Y Y VSS VSS sky130_fd_pr__nfet_01v8 w=0.5 l=1.2
XM2_f8 Y Y VSS VSS sky130_fd_pr__nfet_01v8 w=0.5 l=1.2
XM3_f0 IOUT1 IIN1 Y VSS sky130_fd_pr__nfet_01v8 w=0.5 l=1.2
XM3_f1 IOUT1 IIN1 Y VSS sky130_fd_pr__nfet_01v8 w=0.5 l=1.2
XM3_f2 IOUT1 IIN1 Y VSS sky130_fd_pr__nfet_01v8 w=0.5 l=1.2
XM3_f3 IOUT1 IIN1 Y VSS sky130_fd_pr__nfet_01v8 w=0.5 l=1.2
XM3_f4 IOUT1 IIN1 Y VSS sky130_fd_pr__nfet_01v8 w=0.5 l=1.2
XM3_f5 IOUT1 IIN1 Y VSS sky130_fd_pr__nfet_01v8 w=0.5 l=1.2
XM3_f6 IOUT1 IIN1 Y VSS sky130_fd_pr__nfet_01v8 w=0.5 l=1.2
XM3_f7 IOUT1 IIN1 Y VSS sky130_fd_pr__nfet_01v8 w=0.5 l=1.2
XM3_f8 IOUT1 IIN1 Y VSS sky130_fd_pr__nfet_01v8 w=0.5 l=1.2
.ends corpus_c03
