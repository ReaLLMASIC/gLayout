.subckt corpus_c06 VDD VSS VIN1 VOUT1 VB1 VB2 VB3
XM1_f0 VOUT1 VB2 net10 VDD sky130_fd_pr__pfet_01v8 w=0.5 l=0.45
XM1_f1 VOUT1 VB2 net10 VDD sky130_fd_pr__pfet_01v8 w=0.5 l=0.45
XM1_f2 VOUT1 VB2 net10 VDD sky130_fd_pr__pfet_01v8 w=0.5 l=0.45
XM1_f3 VOUT1 VB2 net10 VDD sky130_fd_pr__pfet_01v8 w=0.5 l=0.45
XM1_f4 VOUT1 VB2 net10 VDD sky130_fd_pr__pfet_01v8 w=0.5 l=0.45
XM1_f5 VOUT1 VB2 net10 VDD sky130_fd_pr__pfet_01v8 w=0.5 l=0.45
XM1_f6 VOUT1 VB2 net10 VDD sky130_fd_pr__pfet_01v8 w=0.5 l=0.45
XM1_f7 VOUT1 VB2 net10 VDD sky130_fd_pr__pfet_01v8 w=0.5 l=0.45
XM2_f0 net10 VB3 VDD VDD sky130_fd_pr__pfet_01v8 w=0.5 l=0.45
XM2_f1 net10 VB3 VDD VDD sky130_fd_pr__pfet_01v8 w=0.5 l=0.45
XM2_f2 net10 VB3 VDD VDD sky130_fd_pr__pfet_01v8 w=0.5 l=0.45
XM2_f3 net10 VB3 VDD VDD sky130_fd_pr__pfet_01v8 w=0.5 l=0.45
XM2_f4 net10 VB3 VDD VDD sky130_fd_pr__pfet_01v8 w=0.5 l=0.45
XM2_f5 net10 VB3 VDD VDD sky130_fd_pr__pfet_01v8 w=0.5 l=0.45
XM2_f6 net10 VB3 VDD VDD sky130_fd_pr__pfet_01v8 w=0.5 l=0.45
XM2_f7 net10 VB3 VDD VDD sky130_fd_pr__pfet_01v8 w=0.5 l=0.45
XM3_f0 net9 VIN1 VSS VSS sky130_fd_pr__nfet_01v8 w=0.5 l=0.45
XM3_f1 net9 VIN1 VSS VSS sky130_fd_pr__nfet_01v8 w=0.5 l=0.45
XM3_f2 net9 VIN1 VSS VSS sky130_fd_pr__nfet_01v8 w=0.5 l=0.45
XM3_f3 net9 VIN1 VSS VSS sky130_fd_pr__nfet_01v8 w=0.5 l=0.45
XM4_f0 VOUT1 VB1 net9 VSS sky130_fd_pr__nfet_01v8 w=0.5 l=0.45
XM4_f1 VOUT1 VB1 net9 VSS sky130_fd_pr__nfet_01v8 w=0.5 l=0.45
XM4_f2 VOUT1 VB1 net9 VSS sky130_fd_pr__nfet_01v8 w=0.5 l=0.45
XM4_f3 VOUT1 VB1 net9 VSS sky130_fd_pr__nfet_01v8 w=0.5 l=0.45
.ends corpus_c06
