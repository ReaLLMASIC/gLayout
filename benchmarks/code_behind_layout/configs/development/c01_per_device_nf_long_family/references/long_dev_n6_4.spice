.subckt corpus_c01 VSS IB1 IOUT1
XM1_f0 IB1 IB1 VSS VSS sky130_fd_pr__nfet_01v8 w=2.5 l=3.0
XM1_f1 IB1 IB1 VSS VSS sky130_fd_pr__nfet_01v8 w=2.5 l=3.0
XM1_f2 IB1 IB1 VSS VSS sky130_fd_pr__nfet_01v8 w=2.5 l=3.0
XM1_f3 IB1 IB1 VSS VSS sky130_fd_pr__nfet_01v8 w=2.5 l=3.0
XM1_f4 IB1 IB1 VSS VSS sky130_fd_pr__nfet_01v8 w=2.5 l=3.0
XM1_f5 IB1 IB1 VSS VSS sky130_fd_pr__nfet_01v8 w=2.5 l=3.0
XM2_f0 IOUT1 IB1 VSS VSS sky130_fd_pr__nfet_01v8 w=3.75 l=3.0
XM2_f1 IOUT1 IB1 VSS VSS sky130_fd_pr__nfet_01v8 w=3.75 l=3.0
XM2_f2 IOUT1 IB1 VSS VSS sky130_fd_pr__nfet_01v8 w=3.75 l=3.0
XM2_f3 IOUT1 IB1 VSS VSS sky130_fd_pr__nfet_01v8 w=3.75 l=3.0
.ends corpus_c01
