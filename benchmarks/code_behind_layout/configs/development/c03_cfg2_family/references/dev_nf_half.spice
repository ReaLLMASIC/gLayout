.subckt corpus_c03 VSS IIN1 IOUT1
XM1_f0 IIN1 Y VSS VSS sky130_fd_pr__nfet_01v8 w=1 l=1.2
XM1_f1 IIN1 Y VSS VSS sky130_fd_pr__nfet_01v8 w=1 l=1.2
XM2_f0 Y Y VSS VSS sky130_fd_pr__nfet_01v8 w=1 l=1.2
XM2_f1 Y Y VSS VSS sky130_fd_pr__nfet_01v8 w=1 l=1.2
XM3_f0 IOUT1 IIN1 Y VSS sky130_fd_pr__nfet_01v8 w=1 l=1.2
XM3_f1 IOUT1 IIN1 Y VSS sky130_fd_pr__nfet_01v8 w=1 l=1.2
.ends corpus_c03
