.subckt corpus_c05 VDD VSS VIN1 VOUT1 VB1
XM1_f0 VOUT1 VB1 VSS VSS sky130_fd_pr__nfet_01v8 w=0.5 l=0.3
XM1_f1 VOUT1 VB1 VSS VSS sky130_fd_pr__nfet_01v8 w=0.5 l=0.3
XM1_f2 VOUT1 VB1 VSS VSS sky130_fd_pr__nfet_01v8 w=0.5 l=0.3
XM1_f3 VOUT1 VB1 VSS VSS sky130_fd_pr__nfet_01v8 w=0.5 l=0.3
XM2_f0 VDD VIN1 VOUT1 VSS sky130_fd_pr__nfet_01v8 w=0.5 l=0.3
XM2_f1 VDD VIN1 VOUT1 VSS sky130_fd_pr__nfet_01v8 w=0.5 l=0.3
XM2_f2 VDD VIN1 VOUT1 VSS sky130_fd_pr__nfet_01v8 w=0.5 l=0.3
XM2_f3 VDD VIN1 VOUT1 VSS sky130_fd_pr__nfet_01v8 w=0.5 l=0.3
XM2_f4 VDD VIN1 VOUT1 VSS sky130_fd_pr__nfet_01v8 w=0.5 l=0.3
XM2_f5 VDD VIN1 VOUT1 VSS sky130_fd_pr__nfet_01v8 w=0.5 l=0.3
XM2_f6 VDD VIN1 VOUT1 VSS sky130_fd_pr__nfet_01v8 w=0.5 l=0.3
XM2_f7 VDD VIN1 VOUT1 VSS sky130_fd_pr__nfet_01v8 w=0.5 l=0.3
.ends corpus_c05
