.subckt corpus_c01 VSS IB1 IOUT1
XM1_f0 IB1 IB1 VSS VSS sky130_fd_pr__nfet_01v8 w=0.5 l=0.3
XM2_f0 IOUT1 IB1 VSS VSS sky130_fd_pr__nfet_01v8 w=0.5 l=0.3
.ends corpus_c01
