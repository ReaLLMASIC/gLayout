* NGSPICE file created from fvf.ext - technology: sky130A

.subckt fvf VBULK VIN VOUT Ib
X0 VOUT.t33 VOUT.t31 VOUT.t32 VOUT.t11 sky130_fd_pr__nfet_01v8 ad=0.39 pd=2.78 as=0 ps=0 w=1 l=1.97
X1 VOUT.t30 VOUT.t28 VOUT.t29 VOUT.t25 sky130_fd_pr__nfet_01v8 ad=0.39 pd=2.78 as=0 ps=0 w=1 l=1.97
X2 VOUT.t27 VOUT.t24 VOUT.t26 VOUT.t25 sky130_fd_pr__nfet_01v8 ad=0.39 pd=2.78 as=0 ps=0 w=1 l=1.97
X3 VOUT.t2 Ib.t2 VOUT.t1 VOUT.t0 sky130_fd_pr__nfet_01v8 ad=0.39 pd=2.78 as=0 ps=0 w=1 l=1.97
X4 VOUT.t23 VOUT.t21 VOUT.t22 VOUT.t7 sky130_fd_pr__nfet_01v8 ad=0.78 pd=4.78 as=0 ps=0 w=2 l=2.37
X5 Ib.t0 VIN.t0 VOUT.t4 VOUT.t3 sky130_fd_pr__nfet_01v8 ad=0.78 pd=4.78 as=0.78 ps=4.78 w=2 l=2.37
X6 VOUT.t20 VOUT.t18 VOUT.t19 VOUT.t15 sky130_fd_pr__nfet_01v8 ad=0.78 pd=4.78 as=0 ps=0 w=2 l=2.37
X7 VOUT.t17 VOUT.t14 VOUT.t16 VOUT.t15 sky130_fd_pr__nfet_01v8 ad=0.78 pd=4.78 as=0 ps=0 w=2 l=2.37
X8 Ib.t1 VIN.t1 VOUT.t5 VOUT.t3 sky130_fd_pr__nfet_01v8 ad=0.78 pd=4.78 as=0.78 ps=4.78 w=2 l=2.37
X9 VOUT.t13 VOUT.t10 VOUT.t12 VOUT.t11 sky130_fd_pr__nfet_01v8 ad=0.39 pd=2.78 as=0 ps=0 w=1 l=1.97
X10 VOUT.t35 Ib.t3 VOUT.t34 VOUT.t0 sky130_fd_pr__nfet_01v8 ad=0.39 pd=2.78 as=0 ps=0 w=1 l=1.97
X11 VOUT.t9 VOUT.t6 VOUT.t8 VOUT.t7 sky130_fd_pr__nfet_01v8 ad=0.78 pd=4.78 as=0 ps=0 w=2 l=2.37
R0 VOUT.n624 VOUT.n313 711.122
R1 VOUT.n513 VOUT.n384 711.122
R2 VOUT.n447 VOUT.n385 711.122
R3 VOUT.n559 VOUT.n558 711.122
R4 VOUT.n227 VOUT.n152 591
R5 VOUT.n229 VOUT.n150 591
R6 VOUT.n629 VOUT.n14 591
R7 VOUT.n293 VOUT.n16 591
R8 VOUT.n624 VOUT.n623 585
R9 VOUT.n622 VOUT.n312 585
R10 VOUT.n621 VOUT.n311 585
R11 VOUT.n626 VOUT.n311 585
R12 VOUT.n620 VOUT.n619 585
R13 VOUT.n618 VOUT.n617 585
R14 VOUT.n616 VOUT.n615 585
R15 VOUT.n614 VOUT.n613 585
R16 VOUT.n612 VOUT.n611 585
R17 VOUT.n610 VOUT.n609 585
R18 VOUT.n608 VOUT.n607 585
R19 VOUT.n606 VOUT.n605 585
R20 VOUT.n604 VOUT.n603 585
R21 VOUT.n602 VOUT.n601 585
R22 VOUT.n600 VOUT.n599 585
R23 VOUT.n597 VOUT.n596 585
R24 VOUT.n595 VOUT.n594 585
R25 VOUT.n593 VOUT.n592 585
R26 VOUT.n591 VOUT.n590 585
R27 VOUT.n589 VOUT.n588 585
R28 VOUT.n587 VOUT.n586 585
R29 VOUT.n585 VOUT.n584 585
R30 VOUT.n583 VOUT.n582 585
R31 VOUT.n581 VOUT.n580 585
R32 VOUT.n579 VOUT.n578 585
R33 VOUT.n577 VOUT.n576 585
R34 VOUT.n575 VOUT.n574 585
R35 VOUT.n573 VOUT.n572 585
R36 VOUT.n571 VOUT.n570 585
R37 VOUT.n569 VOUT.n568 585
R38 VOUT.n567 VOUT.n566 585
R39 VOUT.n564 VOUT.n563 585
R40 VOUT.n562 VOUT.n561 585
R41 VOUT.n560 VOUT.n559 585
R42 VOUT.n448 VOUT.n447 585
R43 VOUT.n450 VOUT.n449 585
R44 VOUT.n452 VOUT.n451 585
R45 VOUT.n455 VOUT.n454 585
R46 VOUT.n457 VOUT.n456 585
R47 VOUT.n459 VOUT.n458 585
R48 VOUT.n461 VOUT.n460 585
R49 VOUT.n463 VOUT.n462 585
R50 VOUT.n465 VOUT.n464 585
R51 VOUT.n467 VOUT.n466 585
R52 VOUT.n469 VOUT.n468 585
R53 VOUT.n471 VOUT.n470 585
R54 VOUT.n473 VOUT.n472 585
R55 VOUT.n475 VOUT.n474 585
R56 VOUT.n477 VOUT.n476 585
R57 VOUT.n479 VOUT.n478 585
R58 VOUT.n481 VOUT.n480 585
R59 VOUT.n483 VOUT.n482 585
R60 VOUT.n485 VOUT.n484 585
R61 VOUT.n488 VOUT.n487 585
R62 VOUT.n490 VOUT.n489 585
R63 VOUT.n492 VOUT.n491 585
R64 VOUT.n494 VOUT.n493 585
R65 VOUT.n496 VOUT.n495 585
R66 VOUT.n498 VOUT.n497 585
R67 VOUT.n500 VOUT.n499 585
R68 VOUT.n502 VOUT.n501 585
R69 VOUT.n504 VOUT.n503 585
R70 VOUT.n506 VOUT.n505 585
R71 VOUT.n507 VOUT.n402 585
R72 VOUT.n509 VOUT.n508 585
R73 VOUT.n404 VOUT.n401 585
R74 VOUT.n403 VOUT.n384 585
R75 VOUT.n511 VOUT.n384 585
R76 VOUT.n445 VOUT.n385 585
R77 VOUT.n512 VOUT.n385 585
R78 VOUT.n444 VOUT.n443 585
R79 VOUT.n443 VOUT.n378 585
R80 VOUT.n442 VOUT.n377 585
R81 VOUT.n518 VOUT.n377 585
R82 VOUT.n410 VOUT.n376 585
R83 VOUT.n519 VOUT.n376 585
R84 VOUT.n438 VOUT.n375 585
R85 VOUT.n520 VOUT.n375 585
R86 VOUT.n437 VOUT.n436 585
R87 VOUT.n436 VOUT.n367 585
R88 VOUT.n435 VOUT.n366 585
R89 VOUT.n526 VOUT.n366 585
R90 VOUT.n412 VOUT.n365 585
R91 VOUT.n527 VOUT.n365 585
R92 VOUT.n431 VOUT.n364 585
R93 VOUT.n528 VOUT.n364 585
R94 VOUT.n430 VOUT.n429 585
R95 VOUT.n429 VOUT.n356 585
R96 VOUT.n428 VOUT.n355 585
R97 VOUT.n534 VOUT.n355 585
R98 VOUT.n414 VOUT.n354 585
R99 VOUT.n535 VOUT.n354 585
R100 VOUT.n424 VOUT.n353 585
R101 VOUT.n536 VOUT.n353 585
R102 VOUT.n423 VOUT.n422 585
R103 VOUT.n422 VOUT.n345 585
R104 VOUT.n421 VOUT.n344 585
R105 VOUT.n542 VOUT.n344 585
R106 VOUT.n416 VOUT.n343 585
R107 VOUT.n543 VOUT.n343 585
R108 VOUT.n417 VOUT.n342 585
R109 VOUT.n544 VOUT.n342 585
R110 VOUT.n325 VOUT.n323 585
R111 VOUT.n326 VOUT.n325 585
R112 VOUT.n552 VOUT.n551 585
R113 VOUT.n551 VOUT.n550 585
R114 VOUT.n324 VOUT.n321 585
R115 VOUT.n331 VOUT.n324 585
R116 VOUT.n556 VOUT.n320 585
R117 VOUT.n332 VOUT.n320 585
R118 VOUT.n558 VOUT.n557 585
R119 VOUT.n558 VOUT.n310 585
R120 VOUT.n330 VOUT.n313 585
R121 VOUT.n313 VOUT.n310 585
R122 VOUT.n334 VOUT.n333 585
R123 VOUT.n333 VOUT.n332 585
R124 VOUT.n329 VOUT.n327 585
R125 VOUT.n331 VOUT.n327 585
R126 VOUT.n549 VOUT.n548 585
R127 VOUT.n550 VOUT.n549 585
R128 VOUT.n547 VOUT.n328 585
R129 VOUT.n328 VOUT.n326 585
R130 VOUT.n546 VOUT.n545 585
R131 VOUT.n545 VOUT.n544 585
R132 VOUT.n341 VOUT.n340 585
R133 VOUT.n543 VOUT.n341 585
R134 VOUT.n541 VOUT.n540 585
R135 VOUT.n542 VOUT.n541 585
R136 VOUT.n539 VOUT.n346 585
R137 VOUT.n346 VOUT.n345 585
R138 VOUT.n538 VOUT.n537 585
R139 VOUT.n537 VOUT.n536 585
R140 VOUT.n352 VOUT.n351 585
R141 VOUT.n535 VOUT.n352 585
R142 VOUT.n533 VOUT.n532 585
R143 VOUT.n534 VOUT.n533 585
R144 VOUT.n531 VOUT.n357 585
R145 VOUT.n357 VOUT.n356 585
R146 VOUT.n530 VOUT.n529 585
R147 VOUT.n529 VOUT.n528 585
R148 VOUT.n363 VOUT.n362 585
R149 VOUT.n527 VOUT.n363 585
R150 VOUT.n525 VOUT.n524 585
R151 VOUT.n526 VOUT.n525 585
R152 VOUT.n523 VOUT.n368 585
R153 VOUT.n368 VOUT.n367 585
R154 VOUT.n522 VOUT.n521 585
R155 VOUT.n521 VOUT.n520 585
R156 VOUT.n374 VOUT.n373 585
R157 VOUT.n519 VOUT.n374 585
R158 VOUT.n517 VOUT.n516 585
R159 VOUT.n518 VOUT.n517 585
R160 VOUT.n515 VOUT.n379 585
R161 VOUT.n379 VOUT.n378 585
R162 VOUT.n514 VOUT.n513 585
R163 VOUT.n513 VOUT.n512 585
R164 VOUT.n630 VOUT.n629 585
R165 VOUT.n629 VOUT.n628 585
R166 VOUT.n13 VOUT.n11 585
R167 VOUT.n15 VOUT.n13 585
R168 VOUT.n634 VOUT.n10 585
R169 VOUT.n286 VOUT.n10 585
R170 VOUT.n635 VOUT.n9 585
R171 VOUT.n285 VOUT.n9 585
R172 VOUT.n636 VOUT.n8 585
R173 VOUT.n284 VOUT.n8 585
R174 VOUT.n111 VOUT.n6 585
R175 VOUT.n112 VOUT.n111 585
R176 VOUT.n640 VOUT.n5 585
R177 VOUT.n274 VOUT.n5 585
R178 VOUT.n641 VOUT.n4 585
R179 VOUT.n273 VOUT.n4 585
R180 VOUT.n642 VOUT.n3 585
R181 VOUT.n272 VOUT.n3 585
R182 VOUT.n127 VOUT.n1 585
R183 VOUT.n127 VOUT.n119 585
R184 VOUT.n263 VOUT.n262 585
R185 VOUT.n264 VOUT.n263 585
R186 VOUT.n261 VOUT.n126 585
R187 VOUT.n126 VOUT.n125 585
R188 VOUT.n132 VOUT.n128 585
R189 VOUT.n254 VOUT.n132 585
R190 VOUT.n257 VOUT.n256 585
R191 VOUT.n256 VOUT.n255 585
R192 VOUT.n131 VOUT.n130 585
R193 VOUT.n133 VOUT.n131 585
R194 VOUT.n244 VOUT.n243 585
R195 VOUT.n245 VOUT.n244 585
R196 VOUT.n141 VOUT.n140 585
R197 VOUT.n140 VOUT.n139 585
R198 VOUT.n239 VOUT.n238 585
R199 VOUT.n238 VOUT.n237 585
R200 VOUT.n144 VOUT.n143 585
R201 VOUT.n145 VOUT.n144 585
R202 VOUT.n227 VOUT.n226 585
R203 VOUT.n228 VOUT.n227 585
R204 VOUT.n290 VOUT.n16 585
R205 VOUT.n628 VOUT.n16 585
R206 VOUT.n289 VOUT.n288 585
R207 VOUT.n288 VOUT.n15 585
R208 VOUT.n287 VOUT.n109 585
R209 VOUT.n287 VOUT.n286 585
R210 VOUT.n115 VOUT.n110 585
R211 VOUT.n285 VOUT.n110 585
R212 VOUT.n283 VOUT.n282 585
R213 VOUT.n284 VOUT.n283 585
R214 VOUT.n114 VOUT.n113 585
R215 VOUT.n113 VOUT.n112 585
R216 VOUT.n276 VOUT.n275 585
R217 VOUT.n275 VOUT.n274 585
R218 VOUT.n118 VOUT.n117 585
R219 VOUT.n273 VOUT.n118 585
R220 VOUT.n271 VOUT.n270 585
R221 VOUT.n272 VOUT.n271 585
R222 VOUT.n121 VOUT.n120 585
R223 VOUT.n120 VOUT.n119 585
R224 VOUT.n266 VOUT.n265 585
R225 VOUT.n265 VOUT.n264 585
R226 VOUT.n124 VOUT.n123 585
R227 VOUT.n125 VOUT.n124 585
R228 VOUT.n253 VOUT.n252 585
R229 VOUT.n254 VOUT.n253 585
R230 VOUT.n135 VOUT.n134 585
R231 VOUT.n255 VOUT.n134 585
R232 VOUT.n248 VOUT.n247 585
R233 VOUT.n247 VOUT.n133 585
R234 VOUT.n246 VOUT.n137 585
R235 VOUT.n246 VOUT.n245 585
R236 VOUT.n148 VOUT.n138 585
R237 VOUT.n139 VOUT.n138 585
R238 VOUT.n236 VOUT.n235 585
R239 VOUT.n237 VOUT.n236 585
R240 VOUT.n147 VOUT.n146 585
R241 VOUT.n146 VOUT.n145 585
R242 VOUT.n230 VOUT.n229 585
R243 VOUT.n229 VOUT.n228 585
R244 VOUT.n224 VOUT.n152 585
R245 VOUT.n223 VOUT.n222 585
R246 VOUT.n220 VOUT.n153 585
R247 VOUT.n220 VOUT.n151 585
R248 VOUT.n219 VOUT.n218 585
R249 VOUT.n217 VOUT.n216 585
R250 VOUT.n215 VOUT.n155 585
R251 VOUT.n213 VOUT.n212 585
R252 VOUT.n211 VOUT.n156 585
R253 VOUT.n210 VOUT.n209 585
R254 VOUT.n207 VOUT.n157 585
R255 VOUT.n205 VOUT.n204 585
R256 VOUT.n203 VOUT.n158 585
R257 VOUT.n201 VOUT.n200 585
R258 VOUT.n198 VOUT.n161 585
R259 VOUT.n196 VOUT.n195 585
R260 VOUT.n194 VOUT.n162 585
R261 VOUT.n193 VOUT.n192 585
R262 VOUT.n190 VOUT.n163 585
R263 VOUT.n188 VOUT.n187 585
R264 VOUT.n186 VOUT.n164 585
R265 VOUT.n185 VOUT.n184 585
R266 VOUT.n182 VOUT.n165 585
R267 VOUT.n180 VOUT.n179 585
R268 VOUT.n178 VOUT.n166 585
R269 VOUT.n177 VOUT.n176 585
R270 VOUT.n174 VOUT.n173 585
R271 VOUT.n172 VOUT.n171 585
R272 VOUT.n150 VOUT.n149 585
R273 VOUT.n151 VOUT.n150 585
R274 VOUT.n293 VOUT.n292 585
R275 VOUT.n107 VOUT.n30 585
R276 VOUT.n106 VOUT.n105 585
R277 VOUT.n103 VOUT.n102 585
R278 VOUT.n101 VOUT.n100 585
R279 VOUT.n99 VOUT.n98 585
R280 VOUT.n97 VOUT.n96 585
R281 VOUT.n95 VOUT.n94 585
R282 VOUT.n93 VOUT.n92 585
R283 VOUT.n71 VOUT.n70 585
R284 VOUT.n69 VOUT.n68 585
R285 VOUT.n67 VOUT.n66 585
R286 VOUT.n65 VOUT.n64 585
R287 VOUT.n63 VOUT.n62 585
R288 VOUT.n61 VOUT.n60 585
R289 VOUT.n59 VOUT.n58 585
R290 VOUT.n57 VOUT.n56 585
R291 VOUT.n55 VOUT.n54 585
R292 VOUT.n53 VOUT.n52 585
R293 VOUT.n51 VOUT.n50 585
R294 VOUT.n49 VOUT.n48 585
R295 VOUT.n47 VOUT.n46 585
R296 VOUT.n45 VOUT.n44 585
R297 VOUT.n43 VOUT.n42 585
R298 VOUT.n41 VOUT.n40 585
R299 VOUT.n39 VOUT.n38 585
R300 VOUT.n37 VOUT.n36 585
R301 VOUT.n14 VOUT.n12 585
R302 VOUT.n626 VOUT.n310 316.827
R303 VOUT.n512 VOUT.n511 316.827
R304 VOUT.n88 VOUT.t1 304.466
R305 VOUT.n88 VOUT.t34 302.262
R306 VOUT.n627 VOUT.n626 300.661
R307 VOUT.n81 VOUT.n79 289.615
R308 VOUT.n74 VOUT.n72 289.615
R309 VOUT.n228 VOUT.n151 284.498
R310 VOUT.n628 VOUT.n627 284.498
R311 VOUT.n167 VOUT.t27 278.498
R312 VOUT.n159 VOUT.t30 278.498
R313 VOUT.n33 VOUT.t12 278.498
R314 VOUT.n31 VOUT.t32 278.498
R315 VOUT.n89 VOUT.t2 264.649
R316 VOUT.n626 VOUT.n625 256.663
R317 VOUT.n626 VOUT.n295 256.663
R318 VOUT.n626 VOUT.n296 256.663
R319 VOUT.n626 VOUT.n297 256.663
R320 VOUT.n626 VOUT.n298 256.663
R321 VOUT.n626 VOUT.n299 256.663
R322 VOUT.n626 VOUT.n300 256.663
R323 VOUT.n626 VOUT.n301 256.663
R324 VOUT.n626 VOUT.n302 256.663
R325 VOUT.n626 VOUT.n303 256.663
R326 VOUT.n626 VOUT.n304 256.663
R327 VOUT.n626 VOUT.n305 256.663
R328 VOUT.n626 VOUT.n306 256.663
R329 VOUT.n626 VOUT.n307 256.663
R330 VOUT.n626 VOUT.n308 256.663
R331 VOUT.n626 VOUT.n309 256.663
R332 VOUT.n511 VOUT.n386 256.663
R333 VOUT.n511 VOUT.n387 256.663
R334 VOUT.n511 VOUT.n388 256.663
R335 VOUT.n511 VOUT.n389 256.663
R336 VOUT.n511 VOUT.n390 256.663
R337 VOUT.n511 VOUT.n391 256.663
R338 VOUT.n511 VOUT.n392 256.663
R339 VOUT.n511 VOUT.n393 256.663
R340 VOUT.n511 VOUT.n394 256.663
R341 VOUT.n511 VOUT.n395 256.663
R342 VOUT.n511 VOUT.n396 256.663
R343 VOUT.n511 VOUT.n397 256.663
R344 VOUT.n511 VOUT.n398 256.663
R345 VOUT.n511 VOUT.n399 256.663
R346 VOUT.n511 VOUT.n400 256.663
R347 VOUT.n511 VOUT.n510 256.663
R348 VOUT.n221 VOUT.n151 256.663
R349 VOUT.n154 VOUT.n151 256.663
R350 VOUT.n214 VOUT.n151 256.663
R351 VOUT.n208 VOUT.n151 256.663
R352 VOUT.n206 VOUT.n151 256.663
R353 VOUT.n199 VOUT.n151 256.663
R354 VOUT.n197 VOUT.n151 256.663
R355 VOUT.n191 VOUT.n151 256.663
R356 VOUT.n189 VOUT.n151 256.663
R357 VOUT.n183 VOUT.n151 256.663
R358 VOUT.n181 VOUT.n151 256.663
R359 VOUT.n175 VOUT.n151 256.663
R360 VOUT.n170 VOUT.n151 256.663
R361 VOUT.n627 VOUT.n294 256.663
R362 VOUT.n627 VOUT.n29 256.663
R363 VOUT.n627 VOUT.n28 256.663
R364 VOUT.n627 VOUT.n27 256.663
R365 VOUT.n627 VOUT.n26 256.663
R366 VOUT.n627 VOUT.n25 256.663
R367 VOUT.n627 VOUT.n24 256.663
R368 VOUT.n627 VOUT.n23 256.663
R369 VOUT.n627 VOUT.n22 256.663
R370 VOUT.n627 VOUT.n21 256.663
R371 VOUT.n627 VOUT.n20 256.663
R372 VOUT.n627 VOUT.n19 256.663
R373 VOUT.n627 VOUT.n18 256.663
R374 VOUT.n627 VOUT.n17 256.663
R375 VOUT.n90 VOUT.t35 249.881
R376 VOUT.n333 VOUT.n313 240.244
R377 VOUT.n333 VOUT.n327 240.244
R378 VOUT.n549 VOUT.n327 240.244
R379 VOUT.n549 VOUT.n328 240.244
R380 VOUT.n545 VOUT.n328 240.244
R381 VOUT.n545 VOUT.n341 240.244
R382 VOUT.n541 VOUT.n341 240.244
R383 VOUT.n541 VOUT.n346 240.244
R384 VOUT.n537 VOUT.n346 240.244
R385 VOUT.n537 VOUT.n352 240.244
R386 VOUT.n533 VOUT.n352 240.244
R387 VOUT.n533 VOUT.n357 240.244
R388 VOUT.n529 VOUT.n357 240.244
R389 VOUT.n529 VOUT.n363 240.244
R390 VOUT.n525 VOUT.n363 240.244
R391 VOUT.n525 VOUT.n368 240.244
R392 VOUT.n521 VOUT.n368 240.244
R393 VOUT.n521 VOUT.n374 240.244
R394 VOUT.n517 VOUT.n374 240.244
R395 VOUT.n517 VOUT.n379 240.244
R396 VOUT.n513 VOUT.n379 240.244
R397 VOUT.n558 VOUT.n320 240.244
R398 VOUT.n324 VOUT.n320 240.244
R399 VOUT.n551 VOUT.n324 240.244
R400 VOUT.n551 VOUT.n325 240.244
R401 VOUT.n342 VOUT.n325 240.244
R402 VOUT.n343 VOUT.n342 240.244
R403 VOUT.n344 VOUT.n343 240.244
R404 VOUT.n422 VOUT.n344 240.244
R405 VOUT.n422 VOUT.n353 240.244
R406 VOUT.n354 VOUT.n353 240.244
R407 VOUT.n355 VOUT.n354 240.244
R408 VOUT.n429 VOUT.n355 240.244
R409 VOUT.n429 VOUT.n364 240.244
R410 VOUT.n365 VOUT.n364 240.244
R411 VOUT.n366 VOUT.n365 240.244
R412 VOUT.n436 VOUT.n366 240.244
R413 VOUT.n436 VOUT.n375 240.244
R414 VOUT.n376 VOUT.n375 240.244
R415 VOUT.n377 VOUT.n376 240.244
R416 VOUT.n443 VOUT.n377 240.244
R417 VOUT.n443 VOUT.n385 240.244
R418 VOUT.n227 VOUT.n144 240.244
R419 VOUT.n238 VOUT.n144 240.244
R420 VOUT.n238 VOUT.n140 240.244
R421 VOUT.n244 VOUT.n140 240.244
R422 VOUT.n244 VOUT.n131 240.244
R423 VOUT.n256 VOUT.n131 240.244
R424 VOUT.n256 VOUT.n132 240.244
R425 VOUT.n132 VOUT.n126 240.244
R426 VOUT.n263 VOUT.n126 240.244
R427 VOUT.n263 VOUT.n127 240.244
R428 VOUT.n127 VOUT.n3 240.244
R429 VOUT.n4 VOUT.n3 240.244
R430 VOUT.n5 VOUT.n4 240.244
R431 VOUT.n111 VOUT.n5 240.244
R432 VOUT.n111 VOUT.n8 240.244
R433 VOUT.n9 VOUT.n8 240.244
R434 VOUT.n10 VOUT.n9 240.244
R435 VOUT.n13 VOUT.n10 240.244
R436 VOUT.n629 VOUT.n13 240.244
R437 VOUT.n229 VOUT.n146 240.244
R438 VOUT.n236 VOUT.n146 240.244
R439 VOUT.n236 VOUT.n138 240.244
R440 VOUT.n246 VOUT.n138 240.244
R441 VOUT.n247 VOUT.n246 240.244
R442 VOUT.n247 VOUT.n134 240.244
R443 VOUT.n253 VOUT.n134 240.244
R444 VOUT.n253 VOUT.n124 240.244
R445 VOUT.n265 VOUT.n124 240.244
R446 VOUT.n265 VOUT.n120 240.244
R447 VOUT.n271 VOUT.n120 240.244
R448 VOUT.n271 VOUT.n118 240.244
R449 VOUT.n275 VOUT.n118 240.244
R450 VOUT.n275 VOUT.n113 240.244
R451 VOUT.n283 VOUT.n113 240.244
R452 VOUT.n283 VOUT.n110 240.244
R453 VOUT.n287 VOUT.n110 240.244
R454 VOUT.n288 VOUT.n287 240.244
R455 VOUT.n288 VOUT.n16 240.244
R456 VOUT.n168 VOUT.t26 233.892
R457 VOUT.n160 VOUT.t29 233.892
R458 VOUT.n34 VOUT.t13 233.892
R459 VOUT.n32 VOUT.t33 233.892
R460 VOUT.n405 VOUT.t14 228.01
R461 VOUT.n407 VOUT.t18 228.01
R462 VOUT.n317 VOUT.t21 228.01
R463 VOUT.n315 VOUT.t6 228.01
R464 VOUT.n167 VOUT.t24 207.963
R465 VOUT.n159 VOUT.t28 207.963
R466 VOUT.n33 VOUT.t10 207.963
R467 VOUT.n31 VOUT.t31 207.963
R468 VOUT.n82 VOUT.n81 185
R469 VOUT.n75 VOUT.n74 185
R470 VOUT.n405 VOUT.t16 175.381
R471 VOUT.n407 VOUT.t19 175.381
R472 VOUT.n317 VOUT.t23 175.381
R473 VOUT.n315 VOUT.t9 175.381
R474 VOUT.t4 VOUT.n80 167.117
R475 VOUT.t5 VOUT.n73 167.117
R476 VOUT.n401 VOUT.n384 163.367
R477 VOUT.n509 VOUT.n402 163.367
R478 VOUT.n505 VOUT.n504 163.367
R479 VOUT.n501 VOUT.n500 163.367
R480 VOUT.n497 VOUT.n496 163.367
R481 VOUT.n493 VOUT.n492 163.367
R482 VOUT.n489 VOUT.n488 163.367
R483 VOUT.n484 VOUT.n483 163.367
R484 VOUT.n480 VOUT.n479 163.367
R485 VOUT.n476 VOUT.n475 163.367
R486 VOUT.n472 VOUT.n471 163.367
R487 VOUT.n468 VOUT.n467 163.367
R488 VOUT.n464 VOUT.n463 163.367
R489 VOUT.n460 VOUT.n459 163.367
R490 VOUT.n456 VOUT.n455 163.367
R491 VOUT.n451 VOUT.n450 163.367
R492 VOUT.n312 VOUT.n311 163.367
R493 VOUT.n619 VOUT.n311 163.367
R494 VOUT.n617 VOUT.n616 163.367
R495 VOUT.n613 VOUT.n612 163.367
R496 VOUT.n609 VOUT.n608 163.367
R497 VOUT.n605 VOUT.n604 163.367
R498 VOUT.n601 VOUT.n600 163.367
R499 VOUT.n596 VOUT.n595 163.367
R500 VOUT.n592 VOUT.n591 163.367
R501 VOUT.n588 VOUT.n587 163.367
R502 VOUT.n584 VOUT.n583 163.367
R503 VOUT.n580 VOUT.n579 163.367
R504 VOUT.n576 VOUT.n575 163.367
R505 VOUT.n572 VOUT.n571 163.367
R506 VOUT.n568 VOUT.n567 163.367
R507 VOUT.n563 VOUT.n562 163.367
R508 VOUT.n222 VOUT.n220 163.367
R509 VOUT.n220 VOUT.n219 163.367
R510 VOUT.n216 VOUT.n215 163.367
R511 VOUT.n213 VOUT.n156 163.367
R512 VOUT.n209 VOUT.n207 163.367
R513 VOUT.n205 VOUT.n158 163.367
R514 VOUT.n200 VOUT.n198 163.367
R515 VOUT.n196 VOUT.n162 163.367
R516 VOUT.n192 VOUT.n190 163.367
R517 VOUT.n188 VOUT.n164 163.367
R518 VOUT.n184 VOUT.n182 163.367
R519 VOUT.n180 VOUT.n166 163.367
R520 VOUT.n176 VOUT.n174 163.367
R521 VOUT.n171 VOUT.n150 163.367
R522 VOUT.n38 VOUT.n37 163.367
R523 VOUT.n42 VOUT.n41 163.367
R524 VOUT.n46 VOUT.n45 163.367
R525 VOUT.n50 VOUT.n49 163.367
R526 VOUT.n54 VOUT.n53 163.367
R527 VOUT.n58 VOUT.n57 163.367
R528 VOUT.n62 VOUT.n61 163.367
R529 VOUT.n66 VOUT.n65 163.367
R530 VOUT.n70 VOUT.n69 163.367
R531 VOUT.n94 VOUT.n93 163.367
R532 VOUT.n98 VOUT.n97 163.367
R533 VOUT.n102 VOUT.n101 163.367
R534 VOUT.n105 VOUT.n30 163.367
R535 VOUT.n228 VOUT.n145 161.647
R536 VOUT.n237 VOUT.n145 161.647
R537 VOUT.n245 VOUT.n139 161.647
R538 VOUT.n245 VOUT.n133 161.647
R539 VOUT.n255 VOUT.n133 161.647
R540 VOUT.n255 VOUT.n254 161.647
R541 VOUT.n254 VOUT.n125 161.647
R542 VOUT.n264 VOUT.n125 161.647
R543 VOUT.n272 VOUT.n119 161.647
R544 VOUT.n273 VOUT.n272 161.647
R545 VOUT.n274 VOUT.n273 161.647
R546 VOUT.n274 VOUT.n112 161.647
R547 VOUT.n284 VOUT.n112 161.647
R548 VOUT.n285 VOUT.n284 161.647
R549 VOUT.n286 VOUT.n15 161.647
R550 VOUT.n628 VOUT.n15 161.647
R551 VOUT.n332 VOUT.n310 161.647
R552 VOUT.n332 VOUT.n331 161.647
R553 VOUT.n550 VOUT.n326 161.647
R554 VOUT.n544 VOUT.n326 161.647
R555 VOUT.n544 VOUT.n543 161.647
R556 VOUT.n543 VOUT.n542 161.647
R557 VOUT.n542 VOUT.n345 161.647
R558 VOUT.n536 VOUT.n345 161.647
R559 VOUT.n536 VOUT.n535 161.647
R560 VOUT.n534 VOUT.n356 161.647
R561 VOUT.n528 VOUT.n356 161.647
R562 VOUT.n528 VOUT.n527 161.647
R563 VOUT.n527 VOUT.n526 161.647
R564 VOUT.n526 VOUT.n367 161.647
R565 VOUT.n520 VOUT.n367 161.647
R566 VOUT.n520 VOUT.n519 161.647
R567 VOUT.n518 VOUT.n378 161.647
R568 VOUT.n512 VOUT.n378 161.647
R569 VOUT.n331 VOUT.t7 148.714
R570 VOUT.t15 VOUT.n518 148.714
R571 VOUT.n406 VOUT.t17 123.019
R572 VOUT.n408 VOUT.t20 123.019
R573 VOUT.n318 VOUT.t22 123.019
R574 VOUT.n316 VOUT.t8 123.019
R575 VOUT.n237 VOUT.t25 116.385
R576 VOUT.n286 VOUT.t11 116.385
R577 VOUT.n91 VOUT.n90 88.0899
R578 VOUT.n264 VOUT.t0 80.8234
R579 VOUT.t0 VOUT.n119 80.8234
R580 VOUT.n535 VOUT.t3 80.8234
R581 VOUT.t3 VOUT.n534 80.8234
R582 VOUT.n510 VOUT.n509 71.676
R583 VOUT.n505 VOUT.n400 71.676
R584 VOUT.n501 VOUT.n399 71.676
R585 VOUT.n497 VOUT.n398 71.676
R586 VOUT.n493 VOUT.n397 71.676
R587 VOUT.n489 VOUT.n396 71.676
R588 VOUT.n484 VOUT.n395 71.676
R589 VOUT.n480 VOUT.n394 71.676
R590 VOUT.n476 VOUT.n393 71.676
R591 VOUT.n472 VOUT.n392 71.676
R592 VOUT.n468 VOUT.n391 71.676
R593 VOUT.n464 VOUT.n390 71.676
R594 VOUT.n460 VOUT.n389 71.676
R595 VOUT.n456 VOUT.n388 71.676
R596 VOUT.n451 VOUT.n387 71.676
R597 VOUT.n447 VOUT.n386 71.676
R598 VOUT.n625 VOUT.n624 71.676
R599 VOUT.n619 VOUT.n295 71.676
R600 VOUT.n616 VOUT.n296 71.676
R601 VOUT.n612 VOUT.n297 71.676
R602 VOUT.n608 VOUT.n298 71.676
R603 VOUT.n604 VOUT.n299 71.676
R604 VOUT.n600 VOUT.n300 71.676
R605 VOUT.n595 VOUT.n301 71.676
R606 VOUT.n591 VOUT.n302 71.676
R607 VOUT.n587 VOUT.n303 71.676
R608 VOUT.n583 VOUT.n304 71.676
R609 VOUT.n579 VOUT.n305 71.676
R610 VOUT.n575 VOUT.n306 71.676
R611 VOUT.n571 VOUT.n307 71.676
R612 VOUT.n567 VOUT.n308 71.676
R613 VOUT.n562 VOUT.n309 71.676
R614 VOUT.n625 VOUT.n312 71.676
R615 VOUT.n617 VOUT.n295 71.676
R616 VOUT.n613 VOUT.n296 71.676
R617 VOUT.n609 VOUT.n297 71.676
R618 VOUT.n605 VOUT.n298 71.676
R619 VOUT.n601 VOUT.n299 71.676
R620 VOUT.n596 VOUT.n300 71.676
R621 VOUT.n592 VOUT.n301 71.676
R622 VOUT.n588 VOUT.n302 71.676
R623 VOUT.n584 VOUT.n303 71.676
R624 VOUT.n580 VOUT.n304 71.676
R625 VOUT.n576 VOUT.n305 71.676
R626 VOUT.n572 VOUT.n306 71.676
R627 VOUT.n568 VOUT.n307 71.676
R628 VOUT.n563 VOUT.n308 71.676
R629 VOUT.n559 VOUT.n309 71.676
R630 VOUT.n450 VOUT.n386 71.676
R631 VOUT.n455 VOUT.n387 71.676
R632 VOUT.n459 VOUT.n388 71.676
R633 VOUT.n463 VOUT.n389 71.676
R634 VOUT.n467 VOUT.n390 71.676
R635 VOUT.n471 VOUT.n391 71.676
R636 VOUT.n475 VOUT.n392 71.676
R637 VOUT.n479 VOUT.n393 71.676
R638 VOUT.n483 VOUT.n394 71.676
R639 VOUT.n488 VOUT.n395 71.676
R640 VOUT.n492 VOUT.n396 71.676
R641 VOUT.n496 VOUT.n397 71.676
R642 VOUT.n500 VOUT.n398 71.676
R643 VOUT.n504 VOUT.n399 71.676
R644 VOUT.n402 VOUT.n400 71.676
R645 VOUT.n510 VOUT.n401 71.676
R646 VOUT.n221 VOUT.n152 71.676
R647 VOUT.n219 VOUT.n154 71.676
R648 VOUT.n215 VOUT.n214 71.676
R649 VOUT.n208 VOUT.n156 71.676
R650 VOUT.n207 VOUT.n206 71.676
R651 VOUT.n199 VOUT.n158 71.676
R652 VOUT.n198 VOUT.n197 71.676
R653 VOUT.n191 VOUT.n162 71.676
R654 VOUT.n190 VOUT.n189 71.676
R655 VOUT.n183 VOUT.n164 71.676
R656 VOUT.n182 VOUT.n181 71.676
R657 VOUT.n175 VOUT.n166 71.676
R658 VOUT.n174 VOUT.n170 71.676
R659 VOUT.n37 VOUT.n17 71.676
R660 VOUT.n41 VOUT.n18 71.676
R661 VOUT.n45 VOUT.n19 71.676
R662 VOUT.n49 VOUT.n20 71.676
R663 VOUT.n53 VOUT.n21 71.676
R664 VOUT.n57 VOUT.n22 71.676
R665 VOUT.n61 VOUT.n23 71.676
R666 VOUT.n65 VOUT.n24 71.676
R667 VOUT.n69 VOUT.n25 71.676
R668 VOUT.n93 VOUT.n26 71.676
R669 VOUT.n97 VOUT.n27 71.676
R670 VOUT.n101 VOUT.n28 71.676
R671 VOUT.n105 VOUT.n29 71.676
R672 VOUT.n294 VOUT.n293 71.676
R673 VOUT.n222 VOUT.n221 71.676
R674 VOUT.n216 VOUT.n154 71.676
R675 VOUT.n214 VOUT.n213 71.676
R676 VOUT.n209 VOUT.n208 71.676
R677 VOUT.n206 VOUT.n205 71.676
R678 VOUT.n200 VOUT.n199 71.676
R679 VOUT.n197 VOUT.n196 71.676
R680 VOUT.n192 VOUT.n191 71.676
R681 VOUT.n189 VOUT.n188 71.676
R682 VOUT.n184 VOUT.n183 71.676
R683 VOUT.n181 VOUT.n180 71.676
R684 VOUT.n176 VOUT.n175 71.676
R685 VOUT.n171 VOUT.n170 71.676
R686 VOUT.n294 VOUT.n30 71.676
R687 VOUT.n102 VOUT.n29 71.676
R688 VOUT.n98 VOUT.n28 71.676
R689 VOUT.n94 VOUT.n27 71.676
R690 VOUT.n70 VOUT.n26 71.676
R691 VOUT.n66 VOUT.n25 71.676
R692 VOUT.n62 VOUT.n24 71.676
R693 VOUT.n58 VOUT.n23 71.676
R694 VOUT.n54 VOUT.n22 71.676
R695 VOUT.n50 VOUT.n21 71.676
R696 VOUT.n46 VOUT.n20 71.676
R697 VOUT.n42 VOUT.n19 71.676
R698 VOUT.n38 VOUT.n18 71.676
R699 VOUT.n17 VOUT.n14 71.676
R700 VOUT.n86 VOUT.n78 58.1631
R701 VOUT.n406 VOUT.n405 52.3641
R702 VOUT.n408 VOUT.n407 52.3641
R703 VOUT.n318 VOUT.n317 52.3641
R704 VOUT.n316 VOUT.n315 52.3641
R705 VOUT.n81 VOUT.t4 52.3082
R706 VOUT.n74 VOUT.t5 52.3082
R707 VOUT.n86 VOUT.n85 48.0884
R708 VOUT.t25 VOUT.n139 45.2613
R709 VOUT.t11 VOUT.n285 45.2613
R710 VOUT.n168 VOUT.n167 44.6066
R711 VOUT.n160 VOUT.n159 44.6066
R712 VOUT.n34 VOUT.n33 44.6066
R713 VOUT.n32 VOUT.n31 44.6066
R714 VOUT.n486 VOUT.n406 34.3278
R715 VOUT.n453 VOUT.n408 34.3278
R716 VOUT.n565 VOUT.n318 34.3278
R717 VOUT.n598 VOUT.n316 34.3278
R718 VOUT.n169 VOUT.n168 34.3278
R719 VOUT.n202 VOUT.n160 34.3278
R720 VOUT.n35 VOUT.n34 34.3278
R721 VOUT.n104 VOUT.n32 34.3278
R722 VOUT.n403 VOUT.n383 31.609
R723 VOUT.n448 VOUT.n446 31.609
R724 VOUT.n623 VOUT.n314 31.609
R725 VOUT.n560 VOUT.n319 31.609
R726 VOUT.n225 VOUT.n224 26.8956
R727 VOUT.n231 VOUT.n149 26.8956
R728 VOUT.n631 VOUT.n12 26.8956
R729 VOUT.n292 VOUT.n291 26.8956
R730 VOUT.n334 VOUT.n330 19.3944
R731 VOUT.n334 VOUT.n329 19.3944
R732 VOUT.n548 VOUT.n329 19.3944
R733 VOUT.n548 VOUT.n547 19.3944
R734 VOUT.n547 VOUT.n546 19.3944
R735 VOUT.n546 VOUT.n340 19.3944
R736 VOUT.n540 VOUT.n340 19.3944
R737 VOUT.n540 VOUT.n539 19.3944
R738 VOUT.n539 VOUT.n538 19.3944
R739 VOUT.n538 VOUT.n351 19.3944
R740 VOUT.n532 VOUT.n351 19.3944
R741 VOUT.n532 VOUT.n531 19.3944
R742 VOUT.n531 VOUT.n530 19.3944
R743 VOUT.n530 VOUT.n362 19.3944
R744 VOUT.n524 VOUT.n362 19.3944
R745 VOUT.n524 VOUT.n523 19.3944
R746 VOUT.n523 VOUT.n522 19.3944
R747 VOUT.n522 VOUT.n373 19.3944
R748 VOUT.n516 VOUT.n373 19.3944
R749 VOUT.n516 VOUT.n515 19.3944
R750 VOUT.n515 VOUT.n514 19.3944
R751 VOUT.n557 VOUT.n556 19.3944
R752 VOUT.n556 VOUT.n321 19.3944
R753 VOUT.n552 VOUT.n321 19.3944
R754 VOUT.n552 VOUT.n323 19.3944
R755 VOUT.n417 VOUT.n323 19.3944
R756 VOUT.n417 VOUT.n416 19.3944
R757 VOUT.n421 VOUT.n416 19.3944
R758 VOUT.n423 VOUT.n421 19.3944
R759 VOUT.n424 VOUT.n423 19.3944
R760 VOUT.n424 VOUT.n414 19.3944
R761 VOUT.n428 VOUT.n414 19.3944
R762 VOUT.n430 VOUT.n428 19.3944
R763 VOUT.n431 VOUT.n430 19.3944
R764 VOUT.n431 VOUT.n412 19.3944
R765 VOUT.n435 VOUT.n412 19.3944
R766 VOUT.n437 VOUT.n435 19.3944
R767 VOUT.n438 VOUT.n437 19.3944
R768 VOUT.n438 VOUT.n410 19.3944
R769 VOUT.n442 VOUT.n410 19.3944
R770 VOUT.n444 VOUT.n442 19.3944
R771 VOUT.n445 VOUT.n444 19.3944
R772 VOUT.n226 VOUT.n143 19.3944
R773 VOUT.n239 VOUT.n143 19.3944
R774 VOUT.n239 VOUT.n141 19.3944
R775 VOUT.n243 VOUT.n141 19.3944
R776 VOUT.n243 VOUT.n130 19.3944
R777 VOUT.n257 VOUT.n130 19.3944
R778 VOUT.n257 VOUT.n128 19.3944
R779 VOUT.n261 VOUT.n128 19.3944
R780 VOUT.n262 VOUT.n261 19.3944
R781 VOUT.n262 VOUT.n1 19.3944
R782 VOUT.n642 VOUT.n1 19.3944
R783 VOUT.n642 VOUT.n641 19.3944
R784 VOUT.n641 VOUT.n640 19.3944
R785 VOUT.n640 VOUT.n6 19.3944
R786 VOUT.n636 VOUT.n6 19.3944
R787 VOUT.n636 VOUT.n635 19.3944
R788 VOUT.n635 VOUT.n634 19.3944
R789 VOUT.n634 VOUT.n11 19.3944
R790 VOUT.n630 VOUT.n11 19.3944
R791 VOUT.n230 VOUT.n147 19.3944
R792 VOUT.n235 VOUT.n147 19.3944
R793 VOUT.n235 VOUT.n148 19.3944
R794 VOUT.n148 VOUT.n137 19.3944
R795 VOUT.n248 VOUT.n137 19.3944
R796 VOUT.n248 VOUT.n135 19.3944
R797 VOUT.n252 VOUT.n135 19.3944
R798 VOUT.n252 VOUT.n123 19.3944
R799 VOUT.n266 VOUT.n123 19.3944
R800 VOUT.n266 VOUT.n121 19.3944
R801 VOUT.n270 VOUT.n121 19.3944
R802 VOUT.n270 VOUT.n117 19.3944
R803 VOUT.n276 VOUT.n117 19.3944
R804 VOUT.n276 VOUT.n114 19.3944
R805 VOUT.n282 VOUT.n114 19.3944
R806 VOUT.n282 VOUT.n115 19.3944
R807 VOUT.n115 VOUT.n109 19.3944
R808 VOUT.n289 VOUT.n109 19.3944
R809 VOUT.n290 VOUT.n289 19.3944
R810 VOUT.n90 VOUT.n89 18.0638
R811 VOUT.n88 VOUT.n87 13.041
R812 VOUT.n550 VOUT.t7 12.9322
R813 VOUT.n519 VOUT.t15 12.9322
R814 VOUT.n404 VOUT.n403 10.6151
R815 VOUT.n508 VOUT.n404 10.6151
R816 VOUT.n508 VOUT.n507 10.6151
R817 VOUT.n507 VOUT.n506 10.6151
R818 VOUT.n506 VOUT.n503 10.6151
R819 VOUT.n503 VOUT.n502 10.6151
R820 VOUT.n502 VOUT.n499 10.6151
R821 VOUT.n499 VOUT.n498 10.6151
R822 VOUT.n498 VOUT.n495 10.6151
R823 VOUT.n495 VOUT.n494 10.6151
R824 VOUT.n494 VOUT.n491 10.6151
R825 VOUT.n491 VOUT.n490 10.6151
R826 VOUT.n490 VOUT.n487 10.6151
R827 VOUT.n485 VOUT.n482 10.6151
R828 VOUT.n482 VOUT.n481 10.6151
R829 VOUT.n481 VOUT.n478 10.6151
R830 VOUT.n478 VOUT.n477 10.6151
R831 VOUT.n477 VOUT.n474 10.6151
R832 VOUT.n474 VOUT.n473 10.6151
R833 VOUT.n473 VOUT.n470 10.6151
R834 VOUT.n470 VOUT.n469 10.6151
R835 VOUT.n469 VOUT.n466 10.6151
R836 VOUT.n466 VOUT.n465 10.6151
R837 VOUT.n465 VOUT.n462 10.6151
R838 VOUT.n462 VOUT.n461 10.6151
R839 VOUT.n461 VOUT.n458 10.6151
R840 VOUT.n458 VOUT.n457 10.6151
R841 VOUT.n457 VOUT.n454 10.6151
R842 VOUT.n452 VOUT.n449 10.6151
R843 VOUT.n449 VOUT.n448 10.6151
R844 VOUT.n623 VOUT.n622 10.6151
R845 VOUT.n622 VOUT.n621 10.6151
R846 VOUT.n621 VOUT.n620 10.6151
R847 VOUT.n620 VOUT.n618 10.6151
R848 VOUT.n618 VOUT.n615 10.6151
R849 VOUT.n615 VOUT.n614 10.6151
R850 VOUT.n614 VOUT.n611 10.6151
R851 VOUT.n611 VOUT.n610 10.6151
R852 VOUT.n610 VOUT.n607 10.6151
R853 VOUT.n607 VOUT.n606 10.6151
R854 VOUT.n606 VOUT.n603 10.6151
R855 VOUT.n603 VOUT.n602 10.6151
R856 VOUT.n602 VOUT.n599 10.6151
R857 VOUT.n597 VOUT.n594 10.6151
R858 VOUT.n594 VOUT.n593 10.6151
R859 VOUT.n593 VOUT.n590 10.6151
R860 VOUT.n590 VOUT.n589 10.6151
R861 VOUT.n589 VOUT.n586 10.6151
R862 VOUT.n586 VOUT.n585 10.6151
R863 VOUT.n585 VOUT.n582 10.6151
R864 VOUT.n582 VOUT.n581 10.6151
R865 VOUT.n581 VOUT.n578 10.6151
R866 VOUT.n578 VOUT.n577 10.6151
R867 VOUT.n577 VOUT.n574 10.6151
R868 VOUT.n574 VOUT.n573 10.6151
R869 VOUT.n573 VOUT.n570 10.6151
R870 VOUT.n570 VOUT.n569 10.6151
R871 VOUT.n569 VOUT.n566 10.6151
R872 VOUT.n564 VOUT.n561 10.6151
R873 VOUT.n561 VOUT.n560 10.6151
R874 VOUT.n224 VOUT.n223 10.6151
R875 VOUT.n223 VOUT.n153 10.6151
R876 VOUT.n218 VOUT.n153 10.6151
R877 VOUT.n218 VOUT.n217 10.6151
R878 VOUT.n217 VOUT.n155 10.6151
R879 VOUT.n212 VOUT.n155 10.6151
R880 VOUT.n212 VOUT.n211 10.6151
R881 VOUT.n211 VOUT.n210 10.6151
R882 VOUT.n210 VOUT.n157 10.6151
R883 VOUT.n204 VOUT.n157 10.6151
R884 VOUT.n204 VOUT.n203 10.6151
R885 VOUT.n201 VOUT.n161 10.6151
R886 VOUT.n195 VOUT.n161 10.6151
R887 VOUT.n195 VOUT.n194 10.6151
R888 VOUT.n194 VOUT.n193 10.6151
R889 VOUT.n193 VOUT.n163 10.6151
R890 VOUT.n187 VOUT.n163 10.6151
R891 VOUT.n187 VOUT.n186 10.6151
R892 VOUT.n186 VOUT.n185 10.6151
R893 VOUT.n185 VOUT.n165 10.6151
R894 VOUT.n179 VOUT.n165 10.6151
R895 VOUT.n179 VOUT.n178 10.6151
R896 VOUT.n178 VOUT.n177 10.6151
R897 VOUT.n173 VOUT.n172 10.6151
R898 VOUT.n172 VOUT.n149 10.6151
R899 VOUT.n36 VOUT.n12 10.6151
R900 VOUT.n39 VOUT.n36 10.6151
R901 VOUT.n40 VOUT.n39 10.6151
R902 VOUT.n43 VOUT.n40 10.6151
R903 VOUT.n44 VOUT.n43 10.6151
R904 VOUT.n47 VOUT.n44 10.6151
R905 VOUT.n48 VOUT.n47 10.6151
R906 VOUT.n51 VOUT.n48 10.6151
R907 VOUT.n52 VOUT.n51 10.6151
R908 VOUT.n55 VOUT.n52 10.6151
R909 VOUT.n56 VOUT.n55 10.6151
R910 VOUT.n60 VOUT.n59 10.6151
R911 VOUT.n63 VOUT.n60 10.6151
R912 VOUT.n64 VOUT.n63 10.6151
R913 VOUT.n67 VOUT.n64 10.6151
R914 VOUT.n68 VOUT.n67 10.6151
R915 VOUT.n71 VOUT.n68 10.6151
R916 VOUT.n95 VOUT.n92 10.6151
R917 VOUT.n96 VOUT.n95 10.6151
R918 VOUT.n99 VOUT.n96 10.6151
R919 VOUT.n100 VOUT.n99 10.6151
R920 VOUT.n103 VOUT.n100 10.6151
R921 VOUT.n107 VOUT.n106 10.6151
R922 VOUT.n292 VOUT.n107 10.6151
R923 VOUT.n454 VOUT.n453 9.83465
R924 VOUT.n566 VOUT.n565 9.83465
R925 VOUT.n202 VOUT.n201 9.83465
R926 VOUT.n59 VOUT.n35 9.83465
R927 VOUT.n82 VOUT.n80 9.71174
R928 VOUT.n75 VOUT.n73 9.71174
R929 VOUT.n85 VOUT.n84 9.45567
R930 VOUT.n78 VOUT.n77 9.45567
R931 VOUT.n84 VOUT.n83 9.3005
R932 VOUT.n77 VOUT.n76 9.3005
R933 VOUT.n556 VOUT.n555 9.3005
R934 VOUT.n554 VOUT.n321 9.3005
R935 VOUT.n553 VOUT.n552 9.3005
R936 VOUT.n323 VOUT.n322 9.3005
R937 VOUT.n418 VOUT.n417 9.3005
R938 VOUT.n419 VOUT.n416 9.3005
R939 VOUT.n421 VOUT.n420 9.3005
R940 VOUT.n423 VOUT.n415 9.3005
R941 VOUT.n425 VOUT.n424 9.3005
R942 VOUT.n426 VOUT.n414 9.3005
R943 VOUT.n428 VOUT.n427 9.3005
R944 VOUT.n430 VOUT.n413 9.3005
R945 VOUT.n432 VOUT.n431 9.3005
R946 VOUT.n433 VOUT.n412 9.3005
R947 VOUT.n435 VOUT.n434 9.3005
R948 VOUT.n437 VOUT.n411 9.3005
R949 VOUT.n439 VOUT.n438 9.3005
R950 VOUT.n440 VOUT.n410 9.3005
R951 VOUT.n442 VOUT.n441 9.3005
R952 VOUT.n444 VOUT.n409 9.3005
R953 VOUT.n446 VOUT.n445 9.3005
R954 VOUT.n557 VOUT.n319 9.3005
R955 VOUT.n330 VOUT.n314 9.3005
R956 VOUT.n335 VOUT.n334 9.3005
R957 VOUT.n336 VOUT.n329 9.3005
R958 VOUT.n548 VOUT.n337 9.3005
R959 VOUT.n547 VOUT.n338 9.3005
R960 VOUT.n546 VOUT.n339 9.3005
R961 VOUT.n347 VOUT.n340 9.3005
R962 VOUT.n540 VOUT.n348 9.3005
R963 VOUT.n539 VOUT.n349 9.3005
R964 VOUT.n538 VOUT.n350 9.3005
R965 VOUT.n358 VOUT.n351 9.3005
R966 VOUT.n532 VOUT.n359 9.3005
R967 VOUT.n531 VOUT.n360 9.3005
R968 VOUT.n530 VOUT.n361 9.3005
R969 VOUT.n369 VOUT.n362 9.3005
R970 VOUT.n524 VOUT.n370 9.3005
R971 VOUT.n523 VOUT.n371 9.3005
R972 VOUT.n522 VOUT.n372 9.3005
R973 VOUT.n380 VOUT.n373 9.3005
R974 VOUT.n516 VOUT.n381 9.3005
R975 VOUT.n515 VOUT.n382 9.3005
R976 VOUT.n514 VOUT.n383 9.3005
R977 VOUT.n232 VOUT.n147 9.3005
R978 VOUT.n235 VOUT.n234 9.3005
R979 VOUT.n233 VOUT.n148 9.3005
R980 VOUT.n137 VOUT.n136 9.3005
R981 VOUT.n249 VOUT.n248 9.3005
R982 VOUT.n250 VOUT.n135 9.3005
R983 VOUT.n252 VOUT.n251 9.3005
R984 VOUT.n123 VOUT.n122 9.3005
R985 VOUT.n267 VOUT.n266 9.3005
R986 VOUT.n268 VOUT.n121 9.3005
R987 VOUT.n270 VOUT.n269 9.3005
R988 VOUT.n117 VOUT.n116 9.3005
R989 VOUT.n277 VOUT.n276 9.3005
R990 VOUT.n278 VOUT.n114 9.3005
R991 VOUT.n282 VOUT.n281 9.3005
R992 VOUT.n280 VOUT.n115 9.3005
R993 VOUT.n279 VOUT.n109 9.3005
R994 VOUT.n289 VOUT.n108 9.3005
R995 VOUT.n291 VOUT.n290 9.3005
R996 VOUT.n231 VOUT.n230 9.3005
R997 VOUT.n143 VOUT.n142 9.3005
R998 VOUT.n240 VOUT.n239 9.3005
R999 VOUT.n241 VOUT.n141 9.3005
R1000 VOUT.n243 VOUT.n242 9.3005
R1001 VOUT.n130 VOUT.n129 9.3005
R1002 VOUT.n258 VOUT.n257 9.3005
R1003 VOUT.n259 VOUT.n128 9.3005
R1004 VOUT.n261 VOUT.n260 9.3005
R1005 VOUT.n262 VOUT.n0 9.3005
R1006 VOUT.n226 VOUT.n225 9.3005
R1007 VBULK VOUT.n1 9.3005
R1008 VOUT.n643 VOUT.n642 9.3005
R1009 VOUT.n641 VOUT.n2 9.3005
R1010 VOUT.n640 VOUT.n639 9.3005
R1011 VOUT.n638 VOUT.n6 9.3005
R1012 VOUT.n637 VOUT.n636 9.3005
R1013 VOUT.n635 VOUT.n7 9.3005
R1014 VOUT.n634 VOUT.n633 9.3005
R1015 VOUT.n632 VOUT.n11 9.3005
R1016 VOUT.n631 VOUT.n630 9.3005
R1017 VOUT.n92 VOUT.n91 8.42977
R1018 VOUT.n85 VOUT.n79 8.14595
R1019 VOUT.n78 VOUT.n72 8.14595
R1020 VOUT.n83 VOUT.n82 7.3702
R1021 VOUT.n76 VOUT.n75 7.3702
R1022 VOUT.n487 VOUT.n486 6.0883
R1023 VOUT.n599 VOUT.n598 6.0883
R1024 VOUT.n83 VOUT.n79 5.81868
R1025 VOUT.n76 VOUT.n72 5.81868
R1026 VOUT.n173 VOUT.n169 5.46391
R1027 VOUT.n106 VOUT.n104 5.46391
R1028 VOUT.n87 VOUT.n86 5.15639
R1029 VOUT.n177 VOUT.n169 5.15172
R1030 VOUT.n104 VOUT.n103 5.15172
R1031 VOUT.n486 VOUT.n485 4.52733
R1032 VOUT.n598 VOUT.n597 4.52733
R1033 VOUT.n84 VOUT.n80 3.44771
R1034 VOUT.n77 VOUT.n73 3.44771
R1035 VOUT.n91 VOUT.n71 2.18587
R1036 VOUT.n453 VOUT.n452 0.780988
R1037 VOUT.n565 VOUT.n564 0.780988
R1038 VOUT.n203 VOUT.n202 0.780988
R1039 VOUT.n56 VOUT.n35 0.780988
R1040 VOUT.n555 VOUT.n319 0.152939
R1041 VOUT.n555 VOUT.n554 0.152939
R1042 VOUT.n554 VOUT.n553 0.152939
R1043 VOUT.n553 VOUT.n322 0.152939
R1044 VOUT.n418 VOUT.n322 0.152939
R1045 VOUT.n419 VOUT.n418 0.152939
R1046 VOUT.n420 VOUT.n419 0.152939
R1047 VOUT.n420 VOUT.n415 0.152939
R1048 VOUT.n425 VOUT.n415 0.152939
R1049 VOUT.n426 VOUT.n425 0.152939
R1050 VOUT.n427 VOUT.n426 0.152939
R1051 VOUT.n427 VOUT.n413 0.152939
R1052 VOUT.n432 VOUT.n413 0.152939
R1053 VOUT.n433 VOUT.n432 0.152939
R1054 VOUT.n434 VOUT.n433 0.152939
R1055 VOUT.n434 VOUT.n411 0.152939
R1056 VOUT.n439 VOUT.n411 0.152939
R1057 VOUT.n440 VOUT.n439 0.152939
R1058 VOUT.n441 VOUT.n440 0.152939
R1059 VOUT.n441 VOUT.n409 0.152939
R1060 VOUT.n446 VOUT.n409 0.152939
R1061 VOUT.n335 VOUT.n314 0.152939
R1062 VOUT.n336 VOUT.n335 0.152939
R1063 VOUT.n337 VOUT.n336 0.152939
R1064 VOUT.n338 VOUT.n337 0.152939
R1065 VOUT.n339 VOUT.n338 0.152939
R1066 VOUT.n347 VOUT.n339 0.152939
R1067 VOUT.n348 VOUT.n347 0.152939
R1068 VOUT.n349 VOUT.n348 0.152939
R1069 VOUT.n350 VOUT.n349 0.152939
R1070 VOUT.n358 VOUT.n350 0.152939
R1071 VOUT.n359 VOUT.n358 0.152939
R1072 VOUT.n360 VOUT.n359 0.152939
R1073 VOUT.n361 VOUT.n360 0.152939
R1074 VOUT.n369 VOUT.n361 0.152939
R1075 VOUT.n370 VOUT.n369 0.152939
R1076 VOUT.n371 VOUT.n370 0.152939
R1077 VOUT.n372 VOUT.n371 0.152939
R1078 VOUT.n380 VOUT.n372 0.152939
R1079 VOUT.n381 VOUT.n380 0.152939
R1080 VOUT.n382 VOUT.n381 0.152939
R1081 VOUT.n383 VOUT.n382 0.152939
R1082 VOUT.n232 VOUT.n231 0.152939
R1083 VOUT.n234 VOUT.n232 0.152939
R1084 VOUT.n234 VOUT.n233 0.152939
R1085 VOUT.n233 VOUT.n136 0.152939
R1086 VOUT.n249 VOUT.n136 0.152939
R1087 VOUT.n250 VOUT.n249 0.152939
R1088 VOUT.n251 VOUT.n250 0.152939
R1089 VOUT.n251 VOUT.n122 0.152939
R1090 VOUT.n267 VOUT.n122 0.152939
R1091 VOUT.n268 VOUT.n267 0.152939
R1092 VOUT.n269 VOUT.n268 0.152939
R1093 VOUT.n269 VOUT.n116 0.152939
R1094 VOUT.n277 VOUT.n116 0.152939
R1095 VOUT.n278 VOUT.n277 0.152939
R1096 VOUT.n281 VOUT.n278 0.152939
R1097 VOUT.n281 VOUT.n280 0.152939
R1098 VOUT.n280 VOUT.n279 0.152939
R1099 VOUT.n279 VOUT.n108 0.152939
R1100 VOUT.n291 VOUT.n108 0.152939
R1101 VOUT.n225 VOUT.n142 0.152939
R1102 VOUT.n240 VOUT.n142 0.152939
R1103 VOUT.n241 VOUT.n240 0.152939
R1104 VOUT.n242 VOUT.n241 0.152939
R1105 VOUT.n242 VOUT.n129 0.152939
R1106 VOUT.n258 VOUT.n129 0.152939
R1107 VOUT.n259 VOUT.n258 0.152939
R1108 VOUT.n260 VOUT.n259 0.152939
R1109 VOUT.n260 VOUT.n0 0.152939
R1110 VBULK VOUT.n643 0.152939
R1111 VOUT.n643 VOUT.n2 0.152939
R1112 VOUT.n639 VOUT.n2 0.152939
R1113 VOUT.n639 VOUT.n638 0.152939
R1114 VOUT.n638 VOUT.n637 0.152939
R1115 VOUT.n637 VOUT.n7 0.152939
R1116 VOUT.n633 VOUT.n7 0.152939
R1117 VOUT.n633 VOUT.n632 0.152939
R1118 VOUT.n632 VOUT.n631 0.152939
R1119 VBULK VOUT.n0 0.1255
R1120 VOUT.n87 VOUT 0.07175
R1121 VOUT.n89 VOUT.n88 0.0252093
R1122 Ib.n3 Ib.n1 289.615
R1123 Ib.n10 Ib.n8 289.615
R1124 Ib.n4 Ib.n3 185
R1125 Ib.n11 Ib.n10 185
R1126 Ib.t0 Ib.n2 167.117
R1127 Ib.t1 Ib.n9 167.117
R1128 Ib.n15 Ib.n14 97.7613
R1129 Ib.n15 Ib.n7 87.9624
R1130 Ib.n0 Ib.t2 77.9525
R1131 Ib.n0 Ib.t3 73.2951
R1132 Ib.n3 Ib.t0 52.3082
R1133 Ib.n10 Ib.t1 52.3082
R1134 Ib Ib.n0 20.9423
R1135 Ib.n4 Ib.n2 9.71174
R1136 Ib.n11 Ib.n9 9.71174
R1137 Ib.n7 Ib.n6 9.45567
R1138 Ib.n14 Ib.n13 9.45567
R1139 Ib.n6 Ib.n5 9.3005
R1140 Ib.n13 Ib.n12 9.3005
R1141 Ib.n7 Ib.n1 8.14595
R1142 Ib.n14 Ib.n8 8.14595
R1143 Ib.n5 Ib.n4 7.3702
R1144 Ib.n12 Ib.n11 7.3702
R1145 Ib.n5 Ib.n1 5.81868
R1146 Ib.n12 Ib.n8 5.81868
R1147 Ib Ib.n15 5.27074
R1148 Ib.n6 Ib.n2 3.44771
R1149 Ib.n13 Ib.n9 3.44771
R1150 VIN.n0 VIN.t1 81.8275
R1151 VIN.n0 VIN.t0 69.7713
R1152 VIN VIN.n0 0.0149903
C0 VIN Ib 0.696867f
C1 Ib VOUT 11.6612f
C2 VIN VOUT 3.87686f
.ends
